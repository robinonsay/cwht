* cwht TS-012 harmonic LPF, run r1 nominal (2026-09-28); generated by run_lpf.py, do not edit
* _i ideal exact Chebyshev 0.1 dB fc 165 MHz; _b ideal with BOM values;
* _c Coilcraft 1812SMS with parasitics; _w 24 AWG air coils with parasitics. S21 = V(out).
V_i src_i 0 AC 2
RS_i src_i in_i 50
RL_i out_i 0 50
C1_i in_i 0 2.278718e-11
C3_i a1_i 0 4.044839e-11
C5_i a2_i 0 4.044839e-11
C7_i out_i 0 2.278718e-11
L2_i in_i a1_i 6.862000e-08 Rser=0
L4_i a1_i a2_i 7.588279e-08 Rser=0
L6_i a2_i out_i 6.862000e-08 Rser=0
V_b src_b 0 AC 2
RS_b src_b in_b 50
RL_b out_b 0 50
C1_b in_b 0 2.200000e-11
C3_b a1_b 0 3.900000e-11
C5_b a2_b 0 3.900000e-11
C7_b out_b 0 2.200000e-11
L2_b in_b a1_b 6.800000e-08 Rser=0
L4_b a1_b a2_b 8.200000e-08 Rser=0
L6_b a2_b out_b 6.800000e-08 Rser=0
V_c src_c 0 AC 2
RS_c src_c in_c 50
RL_c out_c 0 50
CPC1_c in_c 0 3.489749e-13
C1_c in_c C1x1_c 2.200000e-11
RC1_c C1x1_c C1x2_c 2.000000e-01
LEC1_c C1x2_c C1x3_c 1.000000e-09 Rser=0
LVC1_c C1x3_c 0 8.496433e-10 Rser=0
CPC3_c a1_c 0 3.489749e-13
C3_c a1_c C3x1_c 3.900000e-11
RC3_c C3x1_c C3x2_c 2.000000e-01
LEC3_c C3x2_c C3x3_c 1.000000e-09 Rser=0
LVC3_c C3x3_c 0 8.496433e-10 Rser=0
CPC5_c a2_c 0 3.489749e-13
C5_c a2_c C5x1_c 3.900000e-11
RC5_c C5x1_c C5x2_c 2.000000e-01
LEC5_c C5x2_c C5x3_c 1.000000e-09 Rser=0
LVC5_c C5x3_c 0 8.496433e-10 Rser=0
CPC7_c out_c 0 3.489749e-13
C7_c out_c C7x1_c 2.200000e-11
RC7_c C7x1_c C7x2_c 2.000000e-01
LEC7_c C7x2_c C7x3_c 1.000000e-09 Rser=0
LVC7_c C7x3_c 0 8.496433e-10 Rser=0
LTaL2_c in_c L2y1_c 5.000000e-10 Rser=0
L2_c L2y1_c L2y2_c 6.800000e-08 Rser=0
RL2_c L2y2_c L2y3_c 6.408849e-01
CSL2_c L2y1_c L2y3_c 2.155575e-13
LTbL2_c L2y3_c a1_c 5.000000e-10 Rser=0
LTaL4_c a1_c L4y1_c 5.000000e-10 Rser=0
L4_c L4y1_c L4y2_c 8.200000e-08 Rser=0
RL4_c L4y2_c L4y3_c 7.728318e-01
CSL4_c L4y1_c L4y3_c 2.327846e-13
LTbL4_c L4y3_c a2_c 5.000000e-10 Rser=0
LTaL6_c a2_c L6y1_c 5.000000e-10 Rser=0
L6_c L6y1_c L6y2_c 6.800000e-08 Rser=0
RL6_c L6y2_c L6y3_c 6.408849e-01
CSL6_c L6y1_c L6y3_c 2.155575e-13
LTbL6_c L6y3_c out_c 5.000000e-10 Rser=0
K24_c L2_c L4_c 5.000000e-03
K46_c L4_c L6_c 5.000000e-03
K26_c L2_c L6_c 1.000000e-03
CIO_c in_c out_c 2.000000e-15
V_w src_w 0 AC 2
RS_w src_w in_w 50
RL_w out_w 0 50
CPC1_w in_w 0 3.489749e-13
C1_w in_w C1x1_w 2.200000e-11
RC1_w C1x1_w C1x2_w 2.000000e-01
LEC1_w C1x2_w C1x3_w 1.000000e-09 Rser=0
LVC1_w C1x3_w 0 8.496433e-10 Rser=0
CPC3_w a1_w 0 3.489749e-13
C3_w a1_w C3x1_w 3.900000e-11
RC3_w C3x1_w C3x2_w 2.000000e-01
LEC3_w C3x2_w C3x3_w 1.000000e-09 Rser=0
LVC3_w C3x3_w 0 8.496433e-10 Rser=0
CPC5_w a2_w 0 3.489749e-13
C5_w a2_w C5x1_w 3.900000e-11
RC5_w C5x1_w C5x2_w 2.000000e-01
LEC5_w C5x2_w C5x3_w 1.000000e-09 Rser=0
LVC5_w C5x3_w 0 8.496433e-10 Rser=0
CPC7_w out_w 0 3.489749e-13
C7_w out_w C7x1_w 2.200000e-11
RC7_w C7x1_w C7x2_w 2.000000e-01
LEC7_w C7x2_w C7x3_w 1.000000e-09 Rser=0
LVC7_w C7x3_w 0 8.496433e-10 Rser=0
LTaL2_w in_w L2y1_w 5.000000e-10 Rser=0
L2_w L2y1_w L2y2_w 6.800000e-08 Rser=0
RL2_w L2y2_w L2y3_w 3.596249e-01
CSL2_w L2y1_w L2y3_w 2.242901e-13
LTbL2_w L2y3_w a1_w 5.000000e-10 Rser=0
LTaL4_w a1_w L4y1_w 5.000000e-10 Rser=0
L4_w L4y1_w L4y2_w 8.200000e-08 Rser=0
RL4_w L4y2_w L4y3_w 4.213188e-01
CSL4_w L4y1_w L4y3_w 2.326800e-13
LTbL4_w L4y3_w a2_w 5.000000e-10 Rser=0
LTaL6_w a2_w L6y1_w 5.000000e-10 Rser=0
L6_w L6y1_w L6y2_w 6.800000e-08 Rser=0
RL6_w L6y2_w L6y3_w 3.596249e-01
CSL6_w L6y1_w L6y3_w 2.242901e-13
LTbL6_w L6y3_w out_w 5.000000e-10 Rser=0
K24_w L2_w L4_w 1.500000e-02
K46_w L4_w L6_w 1.500000e-02
K26_w L2_w L6_w 2.000000e-03
CIO_w in_w out_w 2.000000e-15
V_q src_q 0 AC 2
RS_q src_q in_q 50
RL_q out_q 0 50
CPC1_q in_q 0 3.489749e-13
C1_q in_q C1x1_q 2.200000e-11
RC1_q C1x1_q C1x2_q 1.000000e-06
LEC1_q C1x2_q C1x3_q 1.000000e-09 Rser=0
LVC1_q C1x3_q 0 8.496433e-10 Rser=0
CPC3_q a1_q 0 3.489749e-13
C3_q a1_q C3x1_q 3.900000e-11
RC3_q C3x1_q C3x2_q 1.000000e-06
LEC3_q C3x2_q C3x3_q 1.000000e-09 Rser=0
LVC3_q C3x3_q 0 8.496433e-10 Rser=0
CPC5_q a2_q 0 3.489749e-13
C5_q a2_q C5x1_q 3.900000e-11
RC5_q C5x1_q C5x2_q 1.000000e-06
LEC5_q C5x2_q C5x3_q 1.000000e-09 Rser=0
LVC5_q C5x3_q 0 8.496433e-10 Rser=0
CPC7_q out_q 0 3.489749e-13
C7_q out_q C7x1_q 2.200000e-11
RC7_q C7x1_q C7x2_q 1.000000e-06
LEC7_q C7x2_q C7x3_q 1.000000e-09 Rser=0
LVC7_q C7x3_q 0 8.496433e-10 Rser=0
LTaL2_q in_q L2y1_q 5.000000e-10 Rser=0
L2_q L2y1_q L2y2_q 6.800000e-08 Rser=0
RL2_q L2y2_q L2y3_q 6.408849e-01
CSL2_q L2y1_q L2y3_q 2.155575e-13
LTbL2_q L2y3_q a1_q 5.000000e-10 Rser=0
LTaL4_q a1_q L4y1_q 5.000000e-10 Rser=0
L4_q L4y1_q L4y2_q 8.200000e-08 Rser=0
RL4_q L4y2_q L4y3_q 7.728318e-01
CSL4_q L4y1_q L4y3_q 2.327846e-13
LTbL4_q L4y3_q a2_q 5.000000e-10 Rser=0
LTaL6_q a2_q L6y1_q 5.000000e-10 Rser=0
L6_q L6y1_q L6y2_q 6.800000e-08 Rser=0
RL6_q L6y2_q L6y3_q 6.408849e-01
CSL6_q L6y1_q L6y3_q 2.155575e-13
LTbL6_q L6y3_q out_q 5.000000e-10 Rser=0
K24_q L2_q L4_q 5.000000e-03
K46_q L4_q L6_q 5.000000e-03
K26_q L2_q L6_q 1.000000e-03
CIO_q in_q out_q 2.000000e-15
V_e src_e 0 AC 2
RS_e src_e in_e 50
RL_e out_e 0 50
CPC1_e in_e 0 3.489749e-13
C1_e in_e C1x1_e 2.200000e-11
RC1_e C1x1_e C1x2_e 2.000000e-01
LEC1_e C1x2_e C1x3_e 1.000000e-09 Rser=0
LVC1_e C1x3_e 0 8.496433e-10 Rser=0
CPC3_e a1_e 0 3.489749e-13
C3_e a1_e C3x1_e 3.900000e-11
RC3_e C3x1_e C3x2_e 2.000000e-01
LEC3_e C3x2_e C3x3_e 1.000000e-09 Rser=0
LVC3_e C3x3_e 0 8.496433e-10 Rser=0
CPC5_e a2_e 0 3.489749e-13
C5_e a2_e C5x1_e 3.900000e-11
RC5_e C5x1_e C5x2_e 2.000000e-01
LEC5_e C5x2_e C5x3_e 1.000000e-09 Rser=0
LVC5_e C5x3_e 0 8.496433e-10 Rser=0
CPC7_e out_e 0 3.489749e-13
C7_e out_e C7x1_e 2.200000e-11
RC7_e C7x1_e C7x2_e 2.000000e-01
LEC7_e C7x2_e C7x3_e 1.000000e-09 Rser=0
LVC7_e C7x3_e 0 8.496433e-10 Rser=0
LTaL2_e in_e L2y1_e 5.000000e-10 Rser=0
L2_e L2y1_e L2y2_e 6.800000e-08 Rser=0
RL2_e L2y2_e L2y3_e 1.000000e-06
CSL2_e L2y1_e L2y3_e 2.155575e-13
LTbL2_e L2y3_e a1_e 5.000000e-10 Rser=0
LTaL4_e a1_e L4y1_e 5.000000e-10 Rser=0
L4_e L4y1_e L4y2_e 8.200000e-08 Rser=0
RL4_e L4y2_e L4y3_e 1.000000e-06
CSL4_e L4y1_e L4y3_e 2.327846e-13
LTbL4_e L4y3_e a2_e 5.000000e-10 Rser=0
LTaL6_e a2_e L6y1_e 5.000000e-10 Rser=0
L6_e L6y1_e L6y2_e 6.800000e-08 Rser=0
RL6_e L6y2_e L6y3_e 1.000000e-06
CSL6_e L6y1_e L6y3_e 2.155575e-13
LTbL6_e L6y3_e out_e 5.000000e-10 Rser=0
K24_e L2_e L4_e 5.000000e-03
K46_e L4_e L6_e 5.000000e-03
K26_e L2_e L6_e 1.000000e-03
CIO_e in_e out_e 2.000000e-15
.ac lin 3200 0.5e6 1600e6
.save V(in_i) V(out_i) V(in_b) V(out_b) V(in_c) V(out_c) V(in_w) V(out_w) V(out_q) V(out_e)
.meas AC s21_i_146 FIND V(out_i) AT 146000000
.meas AC s21_i_148 FIND V(out_i) AT 148000000
.meas AC s21_i_288 FIND V(out_i) AT 288000000
.meas AC s21_i_432 FIND V(out_i) AT 432000000
.meas AC s21_b_146 FIND V(out_b) AT 146000000
.meas AC s21_b_148 FIND V(out_b) AT 148000000
.meas AC s21_b_288 FIND V(out_b) AT 288000000
.meas AC s21_b_432 FIND V(out_b) AT 432000000
.meas AC s21_c_146 FIND V(out_c) AT 146000000
.meas AC s21_c_148 FIND V(out_c) AT 148000000
.meas AC s21_c_288 FIND V(out_c) AT 288000000
.meas AC s21_c_432 FIND V(out_c) AT 432000000
.meas AC s21_w_146 FIND V(out_w) AT 146000000
.meas AC s21_w_148 FIND V(out_w) AT 148000000
.meas AC s21_w_288 FIND V(out_w) AT 288000000
.meas AC s21_w_432 FIND V(out_w) AT 432000000
.end
