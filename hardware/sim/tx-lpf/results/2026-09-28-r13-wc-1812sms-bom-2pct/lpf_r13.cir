* cwht TS-012 harmonic LPF, run r13 (revision 2): Coilcraft 1812SMS (G, 2 %) and C0G (G, 2 %), BOM values 22/68/39/82 (2026-09-28); generated by run_lpf.py
* steps 1 and 2: every L and C at -tol and +tol (nominal parasitics); steps 3 to 252: uniform
* random over the parameter box (numpy seed 21013, signed coil coupling); steps 253 to 259: worst-case corners
* found by worst_case.py, one per metric (il, att2, att3, atthi, eff2, eff3, effhi). Every value in mc_values.csv.
* S21 = V(out_m), S11 = V(in_m) - 1 (2 V source, 50 ohm).
.step param run 1 259 1
.param C1C=table(run, 1,2.156000e-11, 2,2.244000e-11, 3,2.209201e-11, 4,2.237116e-11, 5,2.231970e-11, 6,2.190358e-11, 7,2.217510e-11, 8,2.214249e-11,
+ 9,2.190644e-11, 10,2.187693e-11, 11,2.189445e-11, 12,2.161747e-11, 13,2.165131e-11, 14,2.208507e-11, 15,2.229221e-11, 16,2.228033e-11,
+ 17,2.231511e-11, 18,2.157009e-11, 19,2.181228e-11, 20,2.223912e-11, 21,2.161741e-11, 22,2.158341e-11, 23,2.209173e-11, 24,2.224006e-11,
+ 25,2.190907e-11, 26,2.222323e-11, 27,2.213250e-11, 28,2.216033e-11, 29,2.177022e-11, 30,2.162262e-11, 31,2.207998e-11, 32,2.220338e-11,
+ 33,2.232522e-11, 34,2.189114e-11, 35,2.178921e-11, 36,2.183450e-11, 37,2.229953e-11, 38,2.198052e-11, 39,2.243563e-11, 40,2.219847e-11,
+ 41,2.215450e-11, 42,2.214571e-11, 43,2.222059e-11, 44,2.156703e-11, 45,2.204521e-11, 46,2.159029e-11, 47,2.212724e-11, 48,2.221622e-11,
+ 49,2.182610e-11, 50,2.237731e-11, 51,2.204737e-11, 52,2.211942e-11, 53,2.187338e-11, 54,2.202195e-11, 55,2.176946e-11, 56,2.234618e-11,
+ 57,2.159995e-11, 58,2.197098e-11, 59,2.179023e-11, 60,2.232513e-11, 61,2.231012e-11, 62,2.171974e-11, 63,2.231118e-11, 64,2.163815e-11,
+ 65,2.173427e-11, 66,2.216529e-11, 67,2.200435e-11, 68,2.238463e-11, 69,2.204733e-11, 70,2.205926e-11, 71,2.220840e-11, 72,2.157006e-11,
+ 73,2.172548e-11, 74,2.241702e-11, 75,2.235075e-11, 76,2.177281e-11, 77,2.187289e-11, 78,2.194089e-11, 79,2.211831e-11, 80,2.205374e-11,
+ 81,2.213757e-11, 82,2.166445e-11, 83,2.189477e-11, 84,2.186315e-11, 85,2.181231e-11, 86,2.157988e-11, 87,2.192621e-11, 88,2.176536e-11,
+ 89,2.224611e-11, 90,2.230202e-11, 91,2.203329e-11, 92,2.209583e-11, 93,2.229583e-11, 94,2.229505e-11, 95,2.168774e-11, 96,2.183126e-11,
+ 97,2.175642e-11, 98,2.234275e-11, 99,2.226782e-11, 100,2.218409e-11, 101,2.200941e-11, 102,2.156393e-11, 103,2.172950e-11, 104,2.177175e-11,
+ 105,2.234562e-11, 106,2.221028e-11, 107,2.218303e-11, 108,2.204780e-11, 109,2.214461e-11, 110,2.180176e-11, 111,2.227254e-11, 112,2.157085e-11,
+ 113,2.220503e-11, 114,2.188860e-11, 115,2.181932e-11, 116,2.214758e-11, 117,2.179973e-11, 118,2.192359e-11, 119,2.191577e-11, 120,2.195223e-11,
+ 121,2.195648e-11, 122,2.156756e-11, 123,2.211958e-11, 124,2.203907e-11, 125,2.169990e-11, 126,2.192860e-11, 127,2.206339e-11, 128,2.158803e-11,
+ 129,2.228115e-11, 130,2.217041e-11, 131,2.223577e-11, 132,2.216306e-11, 133,2.171811e-11, 134,2.196935e-11, 135,2.204773e-11, 136,2.188904e-11,
+ 137,2.207061e-11, 138,2.191240e-11, 139,2.186970e-11, 140,2.192169e-11, 141,2.197020e-11, 142,2.184873e-11, 143,2.211325e-11, 144,2.228765e-11,
+ 145,2.221938e-11, 146,2.194259e-11, 147,2.220815e-11, 148,2.165794e-11, 149,2.208861e-11, 150,2.178286e-11, 151,2.205341e-11, 152,2.232081e-11,
+ 153,2.158157e-11, 154,2.195830e-11, 155,2.222453e-11, 156,2.197940e-11, 157,2.223585e-11, 158,2.221033e-11, 159,2.177922e-11, 160,2.180068e-11,
+ 161,2.170386e-11, 162,2.216793e-11, 163,2.176175e-11, 164,2.180612e-11, 165,2.198761e-11, 166,2.197344e-11, 167,2.184053e-11, 168,2.183250e-11,
+ 169,2.237243e-11, 170,2.228217e-11, 171,2.241401e-11, 172,2.216068e-11, 173,2.243885e-11, 174,2.192954e-11, 175,2.191131e-11, 176,2.202263e-11,
+ 177,2.167567e-11, 178,2.207558e-11, 179,2.201797e-11, 180,2.194679e-11, 181,2.178926e-11, 182,2.240315e-11, 183,2.198863e-11, 184,2.208498e-11,
+ 185,2.219752e-11, 186,2.177336e-11, 187,2.209389e-11, 188,2.205881e-11, 189,2.219906e-11, 190,2.214249e-11, 191,2.240554e-11, 192,2.234785e-11,
+ 193,2.183083e-11, 194,2.194458e-11, 195,2.213721e-11, 196,2.187950e-11, 197,2.219582e-11, 198,2.238057e-11, 199,2.172630e-11, 200,2.185057e-11,
+ 201,2.174100e-11, 202,2.237522e-11, 203,2.222448e-11, 204,2.170342e-11, 205,2.160927e-11, 206,2.177678e-11, 207,2.177135e-11, 208,2.209056e-11,
+ 209,2.240430e-11, 210,2.157775e-11, 211,2.209251e-11, 212,2.198634e-11, 213,2.196368e-11, 214,2.226407e-11, 215,2.223462e-11, 216,2.220109e-11,
+ 217,2.204451e-11, 218,2.198827e-11, 219,2.242458e-11, 220,2.158338e-11, 221,2.218987e-11, 222,2.198342e-11, 223,2.208283e-11, 224,2.195841e-11,
+ 225,2.205325e-11, 226,2.178129e-11, 227,2.183302e-11, 228,2.161687e-11, 229,2.198273e-11, 230,2.237372e-11, 231,2.201715e-11, 232,2.238405e-11,
+ 233,2.159738e-11, 234,2.237462e-11, 235,2.212123e-11, 236,2.216830e-11, 237,2.205836e-11, 238,2.204658e-11, 239,2.241563e-11, 240,2.234073e-11,
+ 241,2.211164e-11, 242,2.168402e-11, 243,2.216876e-11, 244,2.196910e-11, 245,2.200692e-11, 246,2.232554e-11, 247,2.226885e-11, 248,2.238474e-11,
+ 249,2.161417e-11, 250,2.203847e-11, 251,2.204209e-11, 252,2.193200e-11, 253,2.156000e-11, 254,2.156000e-11, 255,2.156000e-11, 256,2.244000e-11,
+ 257,2.156000e-11, 258,2.156000e-11, 259,2.244000e-11)
.param C1ESR=table(run, 1,2.000000e-01, 2,2.000000e-01, 3,2.148111e-01, 4,2.658706e-01, 5,1.395583e-01, 6,2.159445e-01, 7,3.692426e-01, 8,3.597486e-01,
+ 9,1.294051e-01, 10,3.648113e-01, 11,1.303760e-01, 12,3.064694e-01, 13,2.681316e-01, 14,3.975455e-01, 15,1.254086e-01, 16,2.008040e-01,
+ 17,2.462409e-01, 18,2.955902e-01, 19,1.396362e-01, 20,3.497652e-01, 21,1.543405e-01, 22,2.274330e-01, 23,1.367297e-01, 24,1.746207e-01,
+ 25,3.599994e-01, 26,3.404425e-01, 27,3.443949e-01, 28,1.865229e-01, 29,2.615633e-01, 30,3.590884e-01, 31,1.949567e-01, 32,2.343418e-01,
+ 33,2.836348e-01, 34,1.699377e-01, 35,1.038578e-01, 36,2.205781e-01, 37,1.328595e-01, 38,1.541975e-01, 39,2.565698e-01, 40,1.042458e-01,
+ 41,1.628397e-01, 42,1.961462e-01, 43,3.618979e-01, 44,1.457177e-01, 45,2.415164e-01, 46,1.555314e-01, 47,1.201798e-01, 48,2.029978e-01,
+ 49,3.690163e-01, 50,1.901024e-01, 51,2.464696e-01, 52,2.031004e-01, 53,2.978381e-01, 54,1.856058e-01, 55,3.356254e-01, 56,3.442411e-01,
+ 57,3.374231e-01, 58,2.560161e-01, 59,2.373211e-01, 60,1.280614e-01, 61,3.326225e-01, 62,3.935942e-01, 63,1.045345e-01, 64,3.255752e-01,
+ 65,2.041541e-01, 66,2.410999e-01, 67,3.475014e-01, 68,1.602892e-01, 69,1.544369e-01, 70,3.069630e-01, 71,3.335321e-01, 72,3.868118e-01,
+ 73,3.392628e-01, 74,1.059964e-01, 75,2.210392e-01, 76,2.042644e-01, 77,3.325972e-01, 78,1.184883e-01, 79,1.568929e-01, 80,1.590907e-01,
+ 81,2.163839e-01, 82,3.019953e-01, 83,2.335638e-01, 84,2.578938e-01, 85,3.224703e-01, 86,1.965524e-01, 87,3.958698e-01, 88,3.276045e-01,
+ 89,1.479812e-01, 90,1.506874e-01, 91,1.158234e-01, 92,1.773592e-01, 93,3.902389e-01, 94,2.876948e-01, 95,2.478086e-01, 96,2.144627e-01,
+ 97,1.784687e-01, 98,2.988165e-01, 99,2.064894e-01, 100,3.720765e-01, 101,1.023616e-01, 102,2.766575e-01, 103,2.945132e-01, 104,3.114361e-01,
+ 105,2.444362e-01, 106,2.528032e-01, 107,1.440552e-01, 108,3.952625e-01, 109,1.995209e-01, 110,1.821258e-01, 111,2.047101e-01, 112,2.253614e-01,
+ 113,3.673753e-01, 114,2.972471e-01, 115,3.318372e-01, 116,3.748298e-01, 117,1.512920e-01, 118,3.275844e-01, 119,3.669727e-01, 120,2.623955e-01,
+ 121,3.110753e-01, 122,3.362808e-01, 123,3.537305e-01, 124,2.121330e-01, 125,1.549020e-01, 126,2.478620e-01, 127,2.642105e-01, 128,3.826329e-01,
+ 129,1.892120e-01, 130,3.536855e-01, 131,1.740036e-01, 132,2.276999e-01, 133,2.794584e-01, 134,3.241438e-01, 135,2.369619e-01, 136,3.895526e-01,
+ 137,3.256796e-01, 138,3.412894e-01, 139,2.636956e-01, 140,2.270280e-01, 141,3.205893e-01, 142,1.969459e-01, 143,3.856590e-01, 144,2.373785e-01,
+ 145,3.263011e-01, 146,2.261607e-01, 147,1.197411e-01, 148,1.942328e-01, 149,3.786682e-01, 150,3.269509e-01, 151,3.771104e-01, 152,2.649311e-01,
+ 153,2.411018e-01, 154,2.493427e-01, 155,3.688062e-01, 156,1.247628e-01, 157,1.712085e-01, 158,3.300600e-01, 159,1.197540e-01, 160,1.425342e-01,
+ 161,2.119461e-01, 162,3.503565e-01, 163,1.270103e-01, 164,2.944541e-01, 165,2.036761e-01, 166,3.515849e-01, 167,3.351178e-01, 168,1.021386e-01,
+ 169,1.954457e-01, 170,3.849044e-01, 171,1.880230e-01, 172,3.042412e-01, 173,2.429600e-01, 174,2.221994e-01, 175,3.930821e-01, 176,1.553944e-01,
+ 177,1.455264e-01, 178,3.666673e-01, 179,2.204094e-01, 180,2.107072e-01, 181,3.134862e-01, 182,3.316644e-01, 183,2.129641e-01, 184,3.583860e-01,
+ 185,2.356569e-01, 186,3.614785e-01, 187,3.989454e-01, 188,2.650234e-01, 189,3.090723e-01, 190,3.292644e-01, 191,1.096860e-01, 192,3.337246e-01,
+ 193,2.310495e-01, 194,2.878584e-01, 195,2.165707e-01, 196,2.825260e-01, 197,3.091586e-01, 198,3.408010e-01, 199,1.550248e-01, 200,3.084710e-01,
+ 201,3.692942e-01, 202,1.651610e-01, 203,1.386177e-01, 204,3.886820e-01, 205,1.180283e-01, 206,3.540498e-01, 207,3.468889e-01, 208,3.973151e-01,
+ 209,3.965841e-01, 210,3.041287e-01, 211,1.857711e-01, 212,1.285370e-01, 213,1.588468e-01, 214,3.668020e-01, 215,3.140455e-01, 216,3.918747e-01,
+ 217,2.653990e-01, 218,2.610297e-01, 219,2.702684e-01, 220,3.436426e-01, 221,2.800221e-01, 222,3.670899e-01, 223,2.231683e-01, 224,1.243007e-01,
+ 225,3.204478e-01, 226,2.456849e-01, 227,1.474418e-01, 228,2.913117e-01, 229,2.333278e-01, 230,2.400795e-01, 231,2.948093e-01, 232,3.988762e-01,
+ 233,3.973248e-01, 234,2.315180e-01, 235,1.222023e-01, 236,3.305502e-01, 237,2.731494e-01, 238,1.011730e-01, 239,2.671083e-01, 240,1.073403e-01,
+ 241,1.614836e-01, 242,1.861072e-01, 243,2.629064e-01, 244,3.094992e-01, 245,3.190496e-01, 246,2.802213e-01, 247,3.023599e-01, 248,1.631070e-01,
+ 249,3.753060e-01, 250,3.829431e-01, 251,2.575136e-01, 252,3.968048e-01, 253,4.000000e-01, 254,1.000000e-01, 255,1.000000e-01, 256,1.000000e-01,
+ 257,1.000000e-01, 258,1.000000e-01, 259,1.000000e-01)
.param C1ESL=table(run, 1,1.000000e-09, 2,1.000000e-09, 3,1.103778e-09, 4,8.312807e-10, 5,8.521289e-10, 6,8.646179e-10, 7,1.152331e-09, 8,1.141073e-09,
+ 9,6.230262e-10, 10,8.489248e-10, 11,8.628067e-10, 12,7.078136e-10, 13,1.098320e-09, 14,1.049468e-09, 15,6.082233e-10, 16,7.673331e-10,
+ 17,7.741585e-10, 18,1.072444e-09, 19,1.186746e-09, 20,6.114068e-10, 21,1.018966e-09, 22,7.728771e-10, 23,1.018690e-09, 24,7.394399e-10,
+ 25,1.170092e-09, 26,7.601668e-10, 27,8.107334e-10, 28,8.051304e-10, 29,1.090593e-09, 30,8.409639e-10, 31,9.703068e-10, 32,7.990926e-10,
+ 33,9.932600e-10, 34,9.192649e-10, 35,8.155015e-10, 36,8.784100e-10, 37,9.600429e-10, 38,6.161076e-10, 39,6.590939e-10, 40,1.083249e-09,
+ 41,6.403003e-10, 42,9.680166e-10, 43,1.058346e-09, 44,8.000773e-10, 45,9.207320e-10, 46,9.929988e-10, 47,6.950033e-10, 48,6.676043e-10,
+ 49,9.502978e-10, 50,1.131636e-09, 51,7.995568e-10, 52,1.143823e-09, 53,6.886656e-10, 54,7.583264e-10, 55,1.140745e-09, 56,8.135389e-10,
+ 57,9.976377e-10, 58,1.026370e-09, 59,7.733959e-10, 60,9.393827e-10, 61,1.184681e-09, 62,9.043130e-10, 63,8.091276e-10, 64,9.854135e-10,
+ 65,8.462926e-10, 66,1.177661e-09, 67,1.014365e-09, 68,1.194325e-09, 69,7.569483e-10, 70,9.539339e-10, 71,9.311562e-10, 72,8.731660e-10,
+ 73,7.693757e-10, 74,8.227388e-10, 75,6.806577e-10, 76,7.465598e-10, 77,1.092595e-09, 78,9.324780e-10, 79,1.173748e-09, 80,6.222298e-10,
+ 81,8.661132e-10, 82,1.092531e-09, 83,1.182637e-09, 84,1.117378e-09, 85,1.016644e-09, 86,1.050148e-09, 87,7.015698e-10, 88,1.124229e-09,
+ 89,6.492655e-10, 90,7.422901e-10, 91,1.106567e-09, 92,9.224020e-10, 93,9.656612e-10, 94,9.791959e-10, 95,1.095538e-09, 96,6.802737e-10,
+ 97,6.609948e-10, 98,6.350586e-10, 99,1.198802e-09, 100,9.112841e-10, 101,9.322136e-10, 102,1.182277e-09, 103,6.810905e-10, 104,9.031651e-10,
+ 105,7.619713e-10, 106,7.025238e-10, 107,9.701448e-10, 108,8.868156e-10, 109,1.199377e-09, 110,1.004631e-09, 111,7.304499e-10, 112,1.198734e-09,
+ 113,8.153460e-10, 114,8.788962e-10, 115,8.046556e-10, 116,6.018704e-10, 117,1.113845e-09, 118,6.882003e-10, 119,9.354138e-10, 120,8.885008e-10,
+ 121,6.631498e-10, 122,9.965473e-10, 123,6.123052e-10, 124,1.189982e-09, 125,7.867542e-10, 126,1.184986e-09, 127,1.123197e-09, 128,8.221098e-10,
+ 129,9.967388e-10, 130,8.447229e-10, 131,1.055269e-09, 132,1.113334e-09, 133,6.199287e-10, 134,1.040446e-09, 135,6.530297e-10, 136,8.719265e-10,
+ 137,1.079409e-09, 138,7.170951e-10, 139,1.099906e-09, 140,6.741045e-10, 141,1.086919e-09, 142,1.022954e-09, 143,7.253670e-10, 144,1.061057e-09,
+ 145,1.047101e-09, 146,6.998183e-10, 147,1.122449e-09, 148,1.157579e-09, 149,1.136843e-09, 150,6.809883e-10, 151,7.016284e-10, 152,1.041767e-09,
+ 153,6.688282e-10, 154,7.899886e-10, 155,6.151469e-10, 156,8.916646e-10, 157,6.933957e-10, 158,6.024244e-10, 159,8.978714e-10, 160,1.022123e-09,
+ 161,9.147402e-10, 162,8.028915e-10, 163,1.079360e-09, 164,7.770944e-10, 165,1.158227e-09, 166,9.895237e-10, 167,8.777939e-10, 168,1.025360e-09,
+ 169,8.406961e-10, 170,6.246523e-10, 171,8.747865e-10, 172,6.139399e-10, 173,6.248832e-10, 174,8.306478e-10, 175,1.003616e-09, 176,8.811718e-10,
+ 177,7.241409e-10, 178,1.103803e-09, 179,1.135336e-09, 180,8.283931e-10, 181,7.042916e-10, 182,9.220242e-10, 183,9.062803e-10, 184,1.176579e-09,
+ 185,9.051978e-10, 186,1.018975e-09, 187,8.890843e-10, 188,1.065363e-09, 189,6.567691e-10, 190,9.619525e-10, 191,7.974658e-10, 192,8.594002e-10,
+ 193,8.006228e-10, 194,9.079314e-10, 195,1.054230e-09, 196,7.855928e-10, 197,6.220355e-10, 198,1.192119e-09, 199,1.022324e-09, 200,8.332410e-10,
+ 201,8.391930e-10, 202,1.059794e-09, 203,1.117473e-09, 204,1.198602e-09, 205,6.391632e-10, 206,8.536316e-10, 207,1.005838e-09, 208,9.775851e-10,
+ 209,1.005163e-09, 210,8.278657e-10, 211,9.425563e-10, 212,9.907205e-10, 213,9.633881e-10, 214,1.171698e-09, 215,9.462517e-10, 216,1.130806e-09,
+ 217,8.341865e-10, 218,6.432526e-10, 219,1.197778e-09, 220,1.007370e-09, 221,8.794289e-10, 222,6.135151e-10, 223,8.330613e-10, 224,7.895300e-10,
+ 225,9.277067e-10, 226,7.619388e-10, 227,1.159434e-09, 228,9.800292e-10, 229,6.013463e-10, 230,9.629270e-10, 231,6.296497e-10, 232,1.061411e-09,
+ 233,7.146082e-10, 234,8.077076e-10, 235,6.307650e-10, 236,7.722117e-10, 237,6.438046e-10, 238,6.779789e-10, 239,6.106128e-10, 240,6.075197e-10,
+ 241,8.952272e-10, 242,1.143995e-09, 243,8.071670e-10, 244,9.235378e-10, 245,1.069075e-09, 246,6.383029e-10, 247,6.719052e-10, 248,9.270665e-10,
+ 249,1.179510e-09, 250,6.644528e-10, 251,8.746290e-10, 252,6.967476e-10, 253,6.000000e-10, 254,6.000000e-10, 255,6.000000e-10, 256,1.200000e-09,
+ 257,6.000000e-10, 258,6.000000e-10, 259,1.200000e-09)
.param C1Lvia=table(run, 1,8.496433e-10, 2,8.496433e-10, 3,1.153050e-09, 4,9.393532e-10, 5,5.811305e-10, 6,1.185954e-09, 7,1.129986e-09, 8,1.008170e-09,
+ 9,5.033190e-10, 10,8.113255e-10, 11,1.241089e-09, 12,1.139270e-09, 13,4.107477e-10, 14,1.259875e-09, 15,6.025919e-10, 16,5.077193e-10,
+ 17,7.885646e-10, 18,1.077824e-09, 19,7.574788e-10, 20,1.183812e-09, 21,7.991550e-10, 22,1.094507e-09, 23,8.886938e-10, 24,1.214543e-09,
+ 25,6.377299e-10, 26,5.072590e-10, 27,6.723886e-10, 28,9.399243e-10, 29,7.720222e-10, 30,9.266142e-10, 31,6.295060e-10, 32,1.193076e-09,
+ 33,9.408750e-10, 34,1.282500e-09, 35,4.423570e-10, 36,5.193084e-10, 37,8.684302e-10, 38,9.759169e-10, 39,8.360253e-10, 40,4.745581e-10,
+ 41,8.766285e-10, 42,1.180061e-09, 43,7.560990e-10, 44,4.843679e-10, 45,4.622222e-10, 46,1.185477e-09, 47,9.171147e-10, 48,1.180454e-09,
+ 49,4.609089e-10, 50,4.200498e-10, 51,1.019789e-09, 52,4.901487e-10, 53,1.078489e-09, 54,4.975477e-10, 55,8.483291e-10, 56,7.067846e-10,
+ 57,1.070957e-09, 58,3.374492e-10, 59,7.552409e-10, 60,4.046807e-10, 61,9.635573e-10, 62,1.251309e-09, 63,4.288386e-10, 64,4.708467e-10,
+ 65,1.256413e-09, 66,5.195807e-10, 67,1.105682e-09, 68,1.200002e-09, 69,5.946104e-10, 70,3.736398e-10, 71,1.183923e-09, 72,3.203189e-10,
+ 73,1.013143e-09, 74,8.794466e-10, 75,3.732191e-10, 76,7.806771e-10, 77,4.491881e-10, 78,9.624693e-10, 79,5.511641e-10, 80,6.333344e-10,
+ 81,4.607548e-10, 82,4.228485e-10, 83,3.572652e-10, 84,7.214145e-10, 85,1.018255e-09, 86,1.159772e-09, 87,7.880164e-10, 88,5.423926e-10,
+ 89,1.134875e-09, 90,5.431710e-10, 91,7.777115e-10, 92,1.067951e-09, 93,4.572946e-10, 94,1.161259e-09, 95,4.198253e-10, 96,5.745763e-10,
+ 97,9.178028e-10, 98,9.708486e-10, 99,3.079027e-10, 100,5.135739e-10, 101,1.066099e-09, 102,9.548901e-10, 103,1.180292e-09, 104,6.642905e-10,
+ 105,7.276306e-10, 106,7.723331e-10, 107,6.510269e-10, 108,4.132332e-10, 109,4.839608e-10, 110,4.506674e-10, 111,3.849763e-10, 112,6.008322e-10,
+ 113,1.095519e-09, 114,1.297020e-09, 115,7.095424e-10, 116,6.352743e-10, 117,8.852288e-10, 118,9.272081e-10, 119,7.291033e-10, 120,3.258570e-10,
+ 121,6.812502e-10, 122,4.240440e-10, 123,3.266218e-10, 124,3.328882e-10, 125,6.027738e-10, 126,1.084344e-09, 127,8.604738e-10, 128,1.226330e-09,
+ 129,1.194516e-09, 130,8.700622e-10, 131,1.288717e-09, 132,5.370060e-10, 133,3.117888e-10, 134,8.892783e-10, 135,9.070975e-10, 136,9.705973e-10,
+ 137,4.199220e-10, 138,4.949475e-10, 139,9.875918e-10, 140,7.465804e-10, 141,1.187712e-09, 142,5.621762e-10, 143,1.045087e-09, 144,5.280020e-10,
+ 145,2.730853e-10, 146,1.173082e-09, 147,3.938841e-10, 148,5.459362e-10, 149,8.482222e-10, 150,8.851906e-10, 151,1.020980e-09, 152,7.716088e-10,
+ 153,9.929749e-10, 154,5.680685e-10, 155,8.951978e-10, 156,3.434917e-10, 157,1.019441e-09, 158,9.453004e-10, 159,3.239317e-10, 160,8.206153e-10,
+ 161,6.989875e-10, 162,4.952209e-10, 163,1.120549e-09, 164,2.763662e-10, 165,6.072339e-10, 166,9.434960e-10, 167,6.811232e-10, 168,3.328866e-10,
+ 169,5.753309e-10, 170,8.177903e-10, 171,6.769252e-10, 172,1.205240e-09, 173,5.929540e-10, 174,1.245049e-09, 175,2.956494e-10, 176,9.936550e-10,
+ 177,1.228895e-09, 178,7.329926e-10, 179,3.377335e-10, 180,1.015424e-09, 181,6.357495e-10, 182,7.757716e-10, 183,3.372653e-10, 184,7.044954e-10,
+ 185,8.340587e-10, 186,9.112419e-10, 187,8.786098e-10, 188,6.068622e-10, 189,6.972927e-10, 190,3.985088e-10, 191,1.280442e-09, 192,1.153679e-09,
+ 193,1.057215e-09, 194,1.189762e-09, 195,3.021091e-10, 196,4.889627e-10, 197,3.875200e-10, 198,5.623356e-10, 199,1.100092e-09, 200,6.253099e-10,
+ 201,9.754841e-10, 202,4.596508e-10, 203,4.063026e-10, 204,1.202061e-09, 205,5.804103e-10, 206,6.903158e-10, 207,1.089975e-09, 208,1.164871e-09,
+ 209,9.414584e-10, 210,5.242158e-10, 211,8.020831e-10, 212,9.203294e-10, 213,5.232991e-10, 214,7.953462e-10, 215,3.515927e-10, 216,1.193226e-09,
+ 217,3.294815e-10, 218,1.238383e-09, 219,5.347024e-10, 220,6.431978e-10, 221,1.134337e-09, 222,8.907395e-10, 223,1.173698e-09, 224,1.225551e-09,
+ 225,1.000666e-09, 226,7.111929e-10, 227,9.353647e-10, 228,1.258402e-09, 229,6.099182e-10, 230,6.792485e-10, 231,9.486561e-10, 232,7.065003e-10,
+ 233,1.028838e-09, 234,7.498047e-10, 235,1.193763e-09, 236,1.236404e-09, 237,1.287284e-09, 238,1.005077e-09, 239,6.109415e-10, 240,1.182854e-09,
+ 241,1.243099e-09, 242,6.764583e-10, 243,1.049646e-09, 244,6.604349e-10, 245,2.984593e-10, 246,9.547447e-10, 247,7.139905e-10, 248,2.832678e-10,
+ 249,1.064874e-09, 250,4.541444e-10, 251,5.768296e-10, 252,4.664806e-10, 253,2.693699e-10, 254,2.693699e-10, 255,2.693699e-10, 256,1.299287e-09,
+ 257,2.693699e-10, 258,2.693699e-10, 259,1.299287e-09)
.param C1Cpad=table(run, 1,3.489749e-13, 2,3.489749e-13, 3,4.461061e-13, 4,2.074990e-13, 5,2.565893e-13, 6,4.649569e-13, 7,2.540282e-13, 8,4.023018e-13,
+ 9,4.340977e-13, 10,5.289440e-13, 11,3.360303e-13, 12,2.856245e-13, 13,4.533340e-13, 14,4.151846e-13, 15,2.779584e-13, 16,4.714065e-13,
+ 17,4.983317e-13, 18,3.583156e-13, 19,3.734008e-13, 20,4.523460e-13, 21,1.734243e-13, 22,2.587085e-13, 23,5.059734e-13, 24,2.458964e-13,
+ 25,5.102820e-13, 26,3.064984e-13, 27,2.803259e-13, 28,5.224354e-13, 29,4.841016e-13, 30,4.351915e-13, 31,3.847758e-13, 32,4.419833e-13,
+ 33,5.188672e-13, 34,2.298076e-13, 35,3.181136e-13, 36,3.108301e-13, 37,5.073782e-13, 38,3.179560e-13, 39,3.831553e-13, 40,3.277345e-13,
+ 41,4.886132e-13, 42,3.282440e-13, 43,1.774953e-13, 44,1.980226e-13, 45,5.260815e-13, 46,2.157366e-13, 47,4.268980e-13, 48,1.800703e-13,
+ 49,5.130950e-13, 50,4.952180e-13, 51,4.513977e-13, 52,2.743195e-13, 53,2.913552e-13, 54,2.113420e-13, 55,4.318934e-13, 56,4.156102e-13,
+ 57,4.302061e-13, 58,4.083564e-13, 59,3.196960e-13, 60,4.254053e-13, 61,4.460449e-13, 62,2.664973e-13, 63,2.429684e-13, 64,3.389303e-13,
+ 65,2.473874e-13, 66,5.122944e-13, 67,4.807415e-13, 68,4.882078e-13, 69,2.514075e-13, 70,2.571069e-13, 71,3.497508e-13, 72,4.658670e-13,
+ 73,3.361003e-13, 74,3.062292e-13, 75,1.956435e-13, 76,5.284458e-13, 77,3.694595e-13, 78,2.587601e-13, 79,3.767759e-13, 80,1.920292e-13,
+ 81,2.445405e-13, 82,4.990261e-13, 83,2.959969e-13, 84,3.226323e-13, 85,3.615590e-13, 86,2.916320e-13, 87,2.003997e-13, 88,1.776170e-13,
+ 89,4.823699e-13, 90,2.954140e-13, 91,3.302590e-13, 92,4.194175e-13, 93,5.064854e-13, 94,2.814074e-13, 95,2.348128e-13, 96,1.979941e-13,
+ 97,4.003372e-13, 98,1.893388e-13, 99,2.382890e-13, 100,5.064297e-13, 101,3.845310e-13, 102,3.349643e-13, 103,4.067771e-13, 104,2.607955e-13,
+ 105,3.270665e-13, 106,2.524798e-13, 107,3.463046e-13, 108,3.826927e-13, 109,3.386881e-13, 110,5.111591e-13, 111,4.909306e-13, 112,2.757682e-13,
+ 113,2.492292e-13, 114,3.946197e-13, 115,3.652425e-13, 116,4.502461e-13, 117,4.700298e-13, 118,4.728068e-13, 119,3.700033e-13, 120,4.404639e-13,
+ 121,4.347553e-13, 122,2.695963e-13, 123,4.713436e-13, 124,4.445433e-13, 125,3.363687e-13, 126,3.127023e-13, 127,5.262761e-13, 128,5.064270e-13,
+ 129,1.735353e-13, 130,1.951793e-13, 131,2.157911e-13, 132,5.236267e-13, 133,4.491927e-13, 134,4.501395e-13, 135,1.749362e-13, 136,3.213211e-13,
+ 137,3.839654e-13, 138,4.520915e-13, 139,2.800321e-13, 140,3.540262e-13, 141,3.743216e-13, 142,2.986564e-13, 143,3.977107e-13, 144,2.160575e-13,
+ 145,4.372133e-13, 146,4.841134e-13, 147,4.760729e-13, 148,2.378442e-13, 149,2.360094e-13, 150,3.123533e-13, 151,3.488057e-13, 152,4.652091e-13,
+ 153,3.763597e-13, 154,2.239742e-13, 155,1.873070e-13, 156,5.105441e-13, 157,4.409942e-13, 158,4.980487e-13, 159,3.501752e-13, 160,4.171001e-13,
+ 161,2.619436e-13, 162,2.249209e-13, 163,4.913287e-13, 164,4.313233e-13, 165,4.940843e-13, 166,4.092183e-13, 167,4.598835e-13, 168,2.163968e-13,
+ 169,2.263032e-13, 170,1.822294e-13, 171,2.569393e-13, 172,3.126352e-13, 173,3.686368e-13, 174,5.075745e-13, 175,5.075261e-13, 176,3.812084e-13,
+ 177,4.389656e-13, 178,4.503071e-13, 179,5.167340e-13, 180,3.923969e-13, 181,1.789157e-13, 182,4.141412e-13, 183,4.796083e-13, 184,2.693120e-13,
+ 185,4.984794e-13, 186,3.323826e-13, 187,3.532034e-13, 188,2.029625e-13, 189,1.883133e-13, 190,1.854261e-13, 191,3.879131e-13, 192,2.413186e-13,
+ 193,2.562147e-13, 194,2.723570e-13, 195,3.158363e-13, 196,2.917999e-13, 197,3.231888e-13, 198,5.221340e-13, 199,2.024989e-13, 200,4.024442e-13,
+ 201,3.383653e-13, 202,3.328469e-13, 203,3.871468e-13, 204,3.824023e-13, 205,2.934106e-13, 206,2.556078e-13, 207,3.322216e-13, 208,2.592435e-13,
+ 209,4.929974e-13, 210,2.453302e-13, 211,2.301106e-13, 212,5.274087e-13, 213,4.662352e-13, 214,1.980769e-13, 215,3.937952e-13, 216,3.069511e-13,
+ 217,3.741709e-13, 218,3.641200e-13, 219,2.572016e-13, 220,4.514785e-13, 221,2.288109e-13, 222,4.823209e-13, 223,2.815584e-13, 224,4.222244e-13,
+ 225,3.191355e-13, 226,1.715119e-13, 227,2.531276e-13, 228,3.920147e-13, 229,5.202402e-13, 230,5.179805e-13, 231,5.048546e-13, 232,3.283834e-13,
+ 233,1.737264e-13, 234,3.792629e-13, 235,4.774237e-13, 236,2.272925e-13, 237,3.870330e-13, 238,3.036628e-13, 239,5.083595e-13, 240,4.469747e-13,
+ 241,3.942561e-13, 242,2.463569e-13, 243,3.362752e-13, 244,1.703226e-13, 245,2.436882e-13, 246,3.991708e-13, 247,5.051587e-13, 248,4.157368e-13,
+ 249,4.030471e-13, 250,3.783891e-13, 251,4.643540e-13, 252,4.816304e-13, 253,1.682769e-13, 254,1.682769e-13, 255,1.682769e-13, 256,5.296728e-13,
+ 257,1.682769e-13, 258,1.682769e-13, 259,5.296728e-13)
.param C3C=table(run, 1,3.822000e-11, 2,3.978000e-11, 3,3.880161e-11, 4,3.841464e-11, 5,3.859204e-11, 6,3.943564e-11, 7,3.933769e-11, 8,3.883455e-11,
+ 9,3.919903e-11, 10,3.935813e-11, 11,3.892574e-11, 12,3.959568e-11, 13,3.954246e-11, 14,3.898746e-11, 15,3.924060e-11, 16,3.944029e-11,
+ 17,3.913105e-11, 18,3.837763e-11, 19,3.969959e-11, 20,3.909314e-11, 21,3.840698e-11, 22,3.844052e-11, 23,3.947996e-11, 24,3.906427e-11,
+ 25,3.862712e-11, 26,3.963685e-11, 27,3.860785e-11, 28,3.839170e-11, 29,3.965328e-11, 30,3.936073e-11, 31,3.943669e-11, 32,3.826922e-11,
+ 33,3.972110e-11, 34,3.949793e-11, 35,3.897968e-11, 36,3.835264e-11, 37,3.959953e-11, 38,3.832919e-11, 39,3.912099e-11, 40,3.940678e-11,
+ 41,3.901393e-11, 42,3.952274e-11, 43,3.971003e-11, 44,3.832430e-11, 45,3.904913e-11, 46,3.881694e-11, 47,3.894243e-11, 48,3.968707e-11,
+ 49,3.975213e-11, 50,3.953786e-11, 51,3.908499e-11, 52,3.861207e-11, 53,3.937102e-11, 54,3.838689e-11, 55,3.904406e-11, 56,3.922134e-11,
+ 57,3.928779e-11, 58,3.972611e-11, 59,3.855468e-11, 60,3.936341e-11, 61,3.907130e-11, 62,3.929416e-11, 63,3.943658e-11, 64,3.973600e-11,
+ 65,3.933649e-11, 66,3.888656e-11, 67,3.865746e-11, 68,3.896842e-11, 69,3.918431e-11, 70,3.971993e-11, 71,3.918551e-11, 72,3.918988e-11,
+ 73,3.824495e-11, 74,3.968299e-11, 75,3.924759e-11, 76,3.886011e-11, 77,3.886124e-11, 78,3.937788e-11, 79,3.865779e-11, 80,3.895786e-11,
+ 81,3.833431e-11, 82,3.884175e-11, 83,3.936677e-11, 84,3.930705e-11, 85,3.855221e-11, 86,3.933098e-11, 87,3.864073e-11, 88,3.938770e-11,
+ 89,3.897805e-11, 90,3.948180e-11, 91,3.844574e-11, 92,3.945108e-11, 93,3.857614e-11, 94,3.841022e-11, 95,3.967017e-11, 96,3.860087e-11,
+ 97,3.862561e-11, 98,3.928065e-11, 99,3.957649e-11, 100,3.833198e-11, 101,3.969525e-11, 102,3.880286e-11, 103,3.922084e-11, 104,3.959001e-11,
+ 105,3.878024e-11, 106,3.879063e-11, 107,3.898030e-11, 108,3.963991e-11, 109,3.849179e-11, 110,3.896230e-11, 111,3.924538e-11, 112,3.869781e-11,
+ 113,3.826025e-11, 114,3.963712e-11, 115,3.877762e-11, 116,3.868224e-11, 117,3.917774e-11, 118,3.915257e-11, 119,3.931689e-11, 120,3.870629e-11,
+ 121,3.829838e-11, 122,3.931531e-11, 123,3.861339e-11, 124,3.891079e-11, 125,3.976890e-11, 126,3.910047e-11, 127,3.874353e-11, 128,3.870647e-11,
+ 129,3.920028e-11, 130,3.874722e-11, 131,3.964332e-11, 132,3.962898e-11, 133,3.896012e-11, 134,3.840632e-11, 135,3.847569e-11, 136,3.945553e-11,
+ 137,3.823505e-11, 138,3.925823e-11, 139,3.822711e-11, 140,3.930018e-11, 141,3.886289e-11, 142,3.948042e-11, 143,3.963873e-11, 144,3.918713e-11,
+ 145,3.964945e-11, 146,3.935934e-11, 147,3.931711e-11, 148,3.931676e-11, 149,3.847524e-11, 150,3.869206e-11, 151,3.962098e-11, 152,3.922354e-11,
+ 153,3.896893e-11, 154,3.860837e-11, 155,3.834582e-11, 156,3.854602e-11, 157,3.826385e-11, 158,3.867012e-11, 159,3.910199e-11, 160,3.832890e-11,
+ 161,3.850945e-11, 162,3.829478e-11, 163,3.888409e-11, 164,3.960306e-11, 165,3.911198e-11, 166,3.933896e-11, 167,3.894055e-11, 168,3.860992e-11,
+ 169,3.834144e-11, 170,3.920483e-11, 171,3.859425e-11, 172,3.867135e-11, 173,3.956359e-11, 174,3.910421e-11, 175,3.833735e-11, 176,3.885651e-11,
+ 177,3.826376e-11, 178,3.898849e-11, 179,3.954320e-11, 180,3.908154e-11, 181,3.865369e-11, 182,3.909462e-11, 183,3.842797e-11, 184,3.836018e-11,
+ 185,3.838570e-11, 186,3.922319e-11, 187,3.967714e-11, 188,3.827623e-11, 189,3.840402e-11, 190,3.945941e-11, 191,3.875045e-11, 192,3.943209e-11,
+ 193,3.870192e-11, 194,3.855931e-11, 195,3.912064e-11, 196,3.975251e-11, 197,3.905007e-11, 198,3.931012e-11, 199,3.945054e-11, 200,3.967035e-11,
+ 201,3.950746e-11, 202,3.832241e-11, 203,3.844397e-11, 204,3.880898e-11, 205,3.898202e-11, 206,3.975653e-11, 207,3.865152e-11, 208,3.863690e-11,
+ 209,3.873346e-11, 210,3.933891e-11, 211,3.860748e-11, 212,3.858459e-11, 213,3.909241e-11, 214,3.913838e-11, 215,3.971073e-11, 216,3.865293e-11,
+ 217,3.846704e-11, 218,3.915411e-11, 219,3.957385e-11, 220,3.951194e-11, 221,3.934774e-11, 222,3.872003e-11, 223,3.877767e-11, 224,3.905283e-11,
+ 225,3.838304e-11, 226,3.845177e-11, 227,3.928324e-11, 228,3.905883e-11, 229,3.852689e-11, 230,3.874963e-11, 231,3.945789e-11, 232,3.914668e-11,
+ 233,3.919160e-11, 234,3.969309e-11, 235,3.897736e-11, 236,3.928075e-11, 237,3.853323e-11, 238,3.955353e-11, 239,3.904154e-11, 240,3.840541e-11,
+ 241,3.927286e-11, 242,3.890550e-11, 243,3.865436e-11, 244,3.914928e-11, 245,3.887336e-11, 246,3.834308e-11, 247,3.859396e-11, 248,3.874570e-11,
+ 249,3.913330e-11, 250,3.914695e-11, 251,3.930674e-11, 252,3.824168e-11, 253,3.978000e-11, 254,3.822000e-11, 255,3.978000e-11, 256,3.978000e-11,
+ 257,3.822000e-11, 258,3.978000e-11, 259,3.978000e-11)
.param C3ESR=table(run, 1,2.000000e-01, 2,2.000000e-01, 3,1.274951e-01, 4,3.311928e-01, 5,1.994087e-01, 6,1.941913e-01, 7,3.626692e-01, 8,2.537398e-01,
+ 9,2.605596e-01, 10,1.899057e-01, 11,2.605369e-01, 12,1.551833e-01, 13,2.129775e-01, 14,3.803147e-01, 15,3.898272e-01, 16,2.889174e-01,
+ 17,1.818142e-01, 18,2.879384e-01, 19,3.530739e-01, 20,2.557615e-01, 21,1.521220e-01, 22,1.527614e-01, 23,1.381882e-01, 24,2.218340e-01,
+ 25,3.881659e-01, 26,2.021036e-01, 27,3.692938e-01, 28,1.332920e-01, 29,2.299645e-01, 30,3.119934e-01, 31,1.478687e-01, 32,1.497378e-01,
+ 33,3.176882e-01, 34,2.834150e-01, 35,2.051629e-01, 36,2.097906e-01, 37,2.140006e-01, 38,1.343516e-01, 39,2.373282e-01, 40,1.748130e-01,
+ 41,1.958700e-01, 42,2.967423e-01, 43,1.886246e-01, 44,3.328982e-01, 45,1.105840e-01, 46,3.870638e-01, 47,1.250950e-01, 48,1.282602e-01,
+ 49,1.129997e-01, 50,1.848463e-01, 51,3.828792e-01, 52,1.277106e-01, 53,1.568770e-01, 54,1.627329e-01, 55,1.962870e-01, 56,3.187953e-01,
+ 57,3.497210e-01, 58,1.825407e-01, 59,3.367621e-01, 60,1.255481e-01, 61,2.581866e-01, 62,2.615464e-01, 63,3.461657e-01, 64,1.708860e-01,
+ 65,1.514029e-01, 66,3.851522e-01, 67,3.375114e-01, 68,3.121402e-01, 69,3.977984e-01, 70,3.105012e-01, 71,3.350537e-01, 72,3.490526e-01,
+ 73,1.830596e-01, 74,1.452362e-01, 75,1.556024e-01, 76,3.986344e-01, 77,1.311456e-01, 78,3.514527e-01, 79,2.188643e-01, 80,1.026718e-01,
+ 81,1.886982e-01, 82,3.543185e-01, 83,3.814228e-01, 84,2.911763e-01, 85,3.855254e-01, 86,1.170798e-01, 87,1.259969e-01, 88,3.710271e-01,
+ 89,2.003849e-01, 90,3.741068e-01, 91,1.544885e-01, 92,2.446035e-01, 93,2.281527e-01, 94,1.502138e-01, 95,2.727087e-01, 96,2.643901e-01,
+ 97,1.730655e-01, 98,3.546457e-01, 99,3.293622e-01, 100,1.355398e-01, 101,2.649443e-01, 102,2.279527e-01, 103,1.651551e-01, 104,1.433805e-01,
+ 105,1.052928e-01, 106,2.875427e-01, 107,3.684885e-01, 108,2.400075e-01, 109,3.314061e-01, 110,3.117819e-01, 111,2.767087e-01, 112,1.490486e-01,
+ 113,1.011494e-01, 114,2.616167e-01, 115,3.298520e-01, 116,1.483013e-01, 117,2.321798e-01, 118,3.317378e-01, 119,3.819213e-01, 120,3.225911e-01,
+ 121,2.083733e-01, 122,1.488772e-01, 123,1.743077e-01, 124,3.643494e-01, 125,3.327708e-01, 126,1.121782e-01, 127,3.971531e-01, 128,2.864128e-01,
+ 129,1.324595e-01, 130,2.667439e-01, 131,2.072020e-01, 132,2.339957e-01, 133,3.738990e-01, 134,3.411568e-01, 135,2.681402e-01, 136,1.884071e-01,
+ 137,1.414964e-01, 138,3.277872e-01, 139,2.412844e-01, 140,2.645878e-01, 141,1.996604e-01, 142,2.719052e-01, 143,1.070411e-01, 144,1.218863e-01,
+ 145,2.880639e-01, 146,2.640997e-01, 147,1.457918e-01, 148,1.686758e-01, 149,3.196796e-01, 150,2.818844e-01, 151,3.260844e-01, 152,1.891084e-01,
+ 153,1.190050e-01, 154,1.926025e-01, 155,3.654797e-01, 156,3.917970e-01, 157,2.586538e-01, 158,1.901638e-01, 159,2.295696e-01, 160,1.246616e-01,
+ 161,2.336346e-01, 162,3.956165e-01, 163,2.579452e-01, 164,1.500139e-01, 165,1.918817e-01, 166,3.404438e-01, 167,1.005500e-01, 168,1.436022e-01,
+ 169,3.747306e-01, 170,2.670917e-01, 171,3.804422e-01, 172,2.851044e-01, 173,3.582757e-01, 174,2.628842e-01, 175,3.996307e-01, 176,1.764625e-01,
+ 177,3.634071e-01, 178,2.939601e-01, 179,1.953541e-01, 180,1.907894e-01, 181,2.026872e-01, 182,3.386548e-01, 183,2.046451e-01, 184,2.486801e-01,
+ 185,1.608811e-01, 186,1.073794e-01, 187,2.110129e-01, 188,2.552300e-01, 189,2.522716e-01, 190,1.773915e-01, 191,3.720079e-01, 192,1.006523e-01,
+ 193,1.027804e-01, 194,2.309185e-01, 195,2.066981e-01, 196,1.660183e-01, 197,1.178073e-01, 198,1.140911e-01, 199,2.072031e-01, 200,1.391343e-01,
+ 201,3.118422e-01, 202,3.705590e-01, 203,2.212020e-01, 204,2.726524e-01, 205,1.577522e-01, 206,3.910845e-01, 207,2.424644e-01, 208,1.415358e-01,
+ 209,2.668337e-01, 210,3.900607e-01, 211,3.223808e-01, 212,1.790777e-01, 213,3.276340e-01, 214,2.506789e-01, 215,1.664031e-01, 216,1.385596e-01,
+ 217,1.614000e-01, 218,3.845062e-01, 219,3.464924e-01, 220,2.614819e-01, 221,2.379786e-01, 222,3.712805e-01, 223,1.751095e-01, 224,2.791773e-01,
+ 225,3.870317e-01, 226,3.249816e-01, 227,3.802241e-01, 228,2.764239e-01, 229,3.838767e-01, 230,2.617083e-01, 231,3.595102e-01, 232,3.887459e-01,
+ 233,1.879094e-01, 234,3.113152e-01, 235,3.919034e-01, 236,1.405882e-01, 237,2.312317e-01, 238,2.637186e-01, 239,3.414808e-01, 240,2.757625e-01,
+ 241,1.710907e-01, 242,2.591075e-01, 243,1.243205e-01, 244,3.105728e-01, 245,3.112239e-01, 246,1.298794e-01, 247,1.078359e-01, 248,2.022576e-01,
+ 249,2.160054e-01, 250,3.616966e-01, 251,3.001172e-01, 252,2.101986e-01, 253,4.000000e-01, 254,1.000000e-01, 255,4.000000e-01, 256,1.000000e-01,
+ 257,4.000000e-01, 258,4.000000e-01, 259,4.000000e-01)
.param C3ESL=table(run, 1,1.000000e-09, 2,1.000000e-09, 3,1.151441e-09, 4,8.660929e-10, 5,8.799220e-10, 6,8.366709e-10, 7,9.101435e-10, 8,7.038399e-10,
+ 9,6.446209e-10, 10,1.169408e-09, 11,1.040765e-09, 12,6.540379e-10, 13,1.197057e-09, 14,1.187583e-09, 15,8.480854e-10, 16,1.006630e-09,
+ 17,7.008275e-10, 18,9.353075e-10, 19,6.817525e-10, 20,1.174446e-09, 21,1.138494e-09, 22,9.862084e-10, 23,1.001266e-09, 24,1.174211e-09,
+ 25,9.464857e-10, 26,1.104901e-09, 27,1.126774e-09, 28,7.744258e-10, 29,8.868491e-10, 30,1.164663e-09, 31,8.869363e-10, 32,8.164763e-10,
+ 33,8.495058e-10, 34,1.157561e-09, 35,1.145285e-09, 36,8.103029e-10, 37,7.367077e-10, 38,6.115340e-10, 39,1.112051e-09, 40,1.092858e-09,
+ 41,9.767936e-10, 42,8.156791e-10, 43,9.800571e-10, 44,8.017354e-10, 45,7.585737e-10, 46,6.250559e-10, 47,9.707867e-10, 48,7.938786e-10,
+ 49,1.184603e-09, 50,9.626108e-10, 51,1.130610e-09, 52,7.417030e-10, 53,7.320146e-10, 54,9.941353e-10, 55,7.692930e-10, 56,6.521371e-10,
+ 57,1.036113e-09, 58,1.127203e-09, 59,7.631068e-10, 60,9.321820e-10, 61,9.766370e-10, 62,6.672133e-10, 63,1.082448e-09, 64,8.336959e-10,
+ 65,6.088862e-10, 66,9.380842e-10, 67,9.210046e-10, 68,7.716560e-10, 69,6.367960e-10, 70,7.069575e-10, 71,6.954463e-10, 72,9.159208e-10,
+ 73,1.079386e-09, 74,8.310438e-10, 75,7.587233e-10, 76,9.191809e-10, 77,1.118474e-09, 78,1.166113e-09, 79,1.045345e-09, 80,6.437614e-10,
+ 81,1.121174e-09, 82,1.127065e-09, 83,9.056359e-10, 84,7.264034e-10, 85,6.416657e-10, 86,9.046757e-10, 87,1.186129e-09, 88,1.143567e-09,
+ 89,8.183432e-10, 90,9.182870e-10, 91,1.159255e-09, 92,9.504776e-10, 93,1.041365e-09, 94,1.162130e-09, 95,6.564470e-10, 96,6.370553e-10,
+ 97,7.244746e-10, 98,1.133051e-09, 99,9.795165e-10, 100,7.540428e-10, 101,1.055374e-09, 102,1.008072e-09, 103,6.281304e-10, 104,9.562797e-10,
+ 105,6.185641e-10, 106,7.279872e-10, 107,7.036733e-10, 108,6.464543e-10, 109,1.192644e-09, 110,9.863269e-10, 111,1.195886e-09, 112,6.437602e-10,
+ 113,9.006883e-10, 114,7.101978e-10, 115,9.212082e-10, 116,6.382695e-10, 117,1.008203e-09, 118,7.493405e-10, 119,1.054190e-09, 120,9.511927e-10,
+ 121,9.962353e-10, 122,9.874360e-10, 123,8.237071e-10, 124,1.173299e-09, 125,8.439482e-10, 126,1.165911e-09, 127,8.086449e-10, 128,6.063657e-10,
+ 129,9.717894e-10, 130,6.498183e-10, 131,9.888178e-10, 132,6.667710e-10, 133,9.814613e-10, 134,6.443859e-10, 135,1.187691e-09, 136,9.419860e-10,
+ 137,9.622999e-10, 138,8.399557e-10, 139,8.943501e-10, 140,9.939660e-10, 141,8.622809e-10, 142,9.188867e-10, 143,1.019945e-09, 144,1.146139e-09,
+ 145,8.811597e-10, 146,8.135385e-10, 147,9.008133e-10, 148,8.601124e-10, 149,9.772956e-10, 150,1.174010e-09, 151,1.041077e-09, 152,7.733035e-10,
+ 153,1.098623e-09, 154,9.106461e-10, 155,7.214405e-10, 156,8.579937e-10, 157,1.040258e-09, 158,1.100448e-09, 159,1.101042e-09, 160,1.018448e-09,
+ 161,1.106962e-09, 162,6.345681e-10, 163,9.801241e-10, 164,7.704924e-10, 165,6.214724e-10, 166,9.757036e-10, 167,7.683198e-10, 168,1.116514e-09,
+ 169,7.597018e-10, 170,8.540118e-10, 171,8.675274e-10, 172,1.171472e-09, 173,9.114171e-10, 174,8.085509e-10, 175,1.150282e-09, 176,1.029971e-09,
+ 177,9.105823e-10, 178,7.045073e-10, 179,7.895394e-10, 180,6.935124e-10, 181,1.026883e-09, 182,7.890522e-10, 183,6.201728e-10, 184,8.136734e-10,
+ 185,9.022350e-10, 186,8.956608e-10, 187,1.199661e-09, 188,6.492693e-10, 189,1.094386e-09, 190,1.137515e-09, 191,6.329408e-10, 192,9.945953e-10,
+ 193,7.017585e-10, 194,8.629065e-10, 195,1.067577e-09, 196,7.084806e-10, 197,6.543172e-10, 198,7.059780e-10, 199,6.407580e-10, 200,8.405180e-10,
+ 201,8.593647e-10, 202,9.950659e-10, 203,8.941747e-10, 204,1.046710e-09, 205,1.135255e-09, 206,7.304134e-10, 207,9.021215e-10, 208,8.891246e-10,
+ 209,1.031093e-09, 210,1.064612e-09, 211,6.377817e-10, 212,7.046577e-10, 213,1.040827e-09, 214,8.437365e-10, 215,1.150422e-09, 216,8.102418e-10,
+ 217,8.038894e-10, 218,1.124395e-09, 219,7.129084e-10, 220,8.574433e-10, 221,1.179600e-09, 222,8.901894e-10, 223,9.488986e-10, 224,1.091757e-09,
+ 225,8.022762e-10, 226,1.090461e-09, 227,8.818424e-10, 228,9.864895e-10, 229,9.430764e-10, 230,9.742017e-10, 231,8.000063e-10, 232,9.820262e-10,
+ 233,6.857670e-10, 234,9.704943e-10, 235,1.166710e-09, 236,9.363372e-10, 237,8.040331e-10, 238,1.090744e-09, 239,8.664707e-10, 240,8.225221e-10,
+ 241,6.357910e-10, 242,1.005895e-09, 243,9.054009e-10, 244,7.745933e-10, 245,1.003590e-09, 246,1.005158e-09, 247,7.694825e-10, 248,7.415091e-10,
+ 249,6.116527e-10, 250,8.196495e-10, 251,1.084700e-09, 252,8.922024e-10, 253,1.200000e-09, 254,6.000000e-10, 255,1.200000e-09, 256,1.200000e-09,
+ 257,6.000000e-10, 258,1.200000e-09, 259,1.200000e-09)
.param C3Lvia=table(run, 1,8.496433e-10, 2,8.496433e-10, 3,7.423756e-10, 4,7.937468e-10, 5,1.127998e-09, 6,4.433282e-10, 7,2.880541e-10, 8,5.048774e-10,
+ 9,8.731104e-10, 10,3.296433e-10, 11,5.975739e-10, 12,4.771798e-10, 13,8.357875e-10, 14,5.698157e-10, 15,5.620787e-10, 16,6.282666e-10,
+ 17,8.299237e-10, 18,4.482691e-10, 19,6.225514e-10, 20,1.230569e-09, 21,6.669417e-10, 22,4.821338e-10, 23,1.010097e-09, 24,8.404317e-10,
+ 25,8.434705e-10, 26,9.393956e-10, 27,1.178662e-09, 28,1.179925e-09, 29,6.737525e-10, 30,5.264049e-10, 31,8.454991e-10, 32,7.364342e-10,
+ 33,1.265111e-09, 34,5.359551e-10, 35,5.977578e-10, 36,3.147512e-10, 37,8.975497e-10, 38,5.038223e-10, 39,7.226342e-10, 40,5.316279e-10,
+ 41,1.162446e-09, 42,3.926113e-10, 43,2.974315e-10, 44,5.740935e-10, 45,5.314434e-10, 46,1.143475e-09, 47,7.817299e-10, 48,3.620667e-10,
+ 49,6.103244e-10, 50,3.048634e-10, 51,6.169968e-10, 52,3.077796e-10, 53,7.156906e-10, 54,6.674492e-10, 55,3.646481e-10, 56,7.309772e-10,
+ 57,7.996572e-10, 58,1.272520e-09, 59,8.695967e-10, 60,4.958288e-10, 61,6.404352e-10, 62,9.027830e-10, 63,7.657243e-10, 64,4.222511e-10,
+ 65,4.765586e-10, 66,9.598735e-10, 67,1.140049e-09, 68,7.830511e-10, 69,8.379899e-10, 70,2.843513e-10, 71,1.128131e-09, 72,1.248046e-09,
+ 73,9.849327e-10, 74,5.524624e-10, 75,1.069754e-09, 76,7.513416e-10, 77,5.114373e-10, 78,1.183776e-09, 79,3.749683e-10, 80,1.017148e-09,
+ 81,6.110954e-10, 82,4.647278e-10, 83,1.285915e-09, 84,4.145905e-10, 85,9.543645e-10, 86,7.640141e-10, 87,3.681702e-10, 88,1.230854e-09,
+ 89,6.103656e-10, 90,1.198189e-09, 91,8.936205e-10, 92,9.140046e-10, 93,1.150945e-09, 94,8.383368e-10, 95,9.006086e-10, 96,1.182542e-09,
+ 97,9.106324e-10, 98,1.009952e-09, 99,5.945696e-10, 100,9.190927e-10, 101,9.569872e-10, 102,2.790662e-10, 103,7.619371e-10, 104,1.075548e-09,
+ 105,7.663570e-10, 106,1.171116e-09, 107,6.180230e-10, 108,5.267857e-10, 109,6.784085e-10, 110,7.216169e-10, 111,5.742135e-10, 112,3.546260e-10,
+ 113,1.218093e-09, 114,1.076554e-09, 115,1.249703e-09, 116,6.341565e-10, 117,7.553890e-10, 118,1.198504e-09, 119,3.481402e-10, 120,3.566268e-10,
+ 121,9.283859e-10, 122,3.150616e-10, 123,2.969731e-10, 124,6.154794e-10, 125,1.147588e-09, 126,1.004610e-09, 127,7.533836e-10, 128,6.365589e-10,
+ 129,1.230384e-09, 130,7.118791e-10, 131,7.184126e-10, 132,2.742333e-10, 133,5.122774e-10, 134,6.034141e-10, 135,1.033422e-09, 136,5.749809e-10,
+ 137,1.268855e-09, 138,1.202713e-09, 139,1.156529e-09, 140,5.420183e-10, 141,8.715010e-10, 142,1.051401e-09, 143,7.597769e-10, 144,9.375563e-10,
+ 145,1.264388e-09, 146,1.090027e-09, 147,9.585272e-10, 148,3.240775e-10, 149,4.878782e-10, 150,1.191647e-09, 151,1.217080e-09, 152,9.414661e-10,
+ 153,1.202906e-09, 154,5.254683e-10, 155,5.224957e-10, 156,1.035895e-09, 157,1.292702e-09, 158,8.661691e-10, 159,4.940071e-10, 160,9.915094e-10,
+ 161,7.789014e-10, 162,7.258634e-10, 163,1.029019e-09, 164,7.725846e-10, 165,1.147183e-09, 166,8.775698e-10, 167,1.001723e-09, 168,1.254896e-09,
+ 169,3.103830e-10, 170,5.946074e-10, 171,6.338080e-10, 172,1.042918e-09, 173,8.323932e-10, 174,3.756806e-10, 175,5.480973e-10, 176,1.262640e-09,
+ 177,4.369573e-10, 178,1.047931e-09, 179,1.125846e-09, 180,1.191158e-09, 181,1.240159e-09, 182,1.071333e-09, 183,1.253834e-09, 184,5.118491e-10,
+ 185,4.301050e-10, 186,1.210908e-09, 187,5.358527e-10, 188,4.957491e-10, 189,1.050667e-09, 190,6.373285e-10, 191,5.575941e-10, 192,5.986207e-10,
+ 193,1.289359e-09, 194,7.825594e-10, 195,9.404607e-10, 196,9.693531e-10, 197,5.554775e-10, 198,1.226531e-09, 199,8.238234e-10, 200,3.411112e-10,
+ 201,4.456193e-10, 202,1.288947e-09, 203,9.423422e-10, 204,1.218600e-09, 205,7.908490e-10, 206,1.174255e-09, 207,1.049409e-09, 208,7.571242e-10,
+ 209,3.758069e-10, 210,7.636288e-10, 211,5.693557e-10, 212,1.176661e-09, 213,7.495469e-10, 214,7.215338e-10, 215,4.451197e-10, 216,4.962376e-10,
+ 217,4.472294e-10, 218,2.925599e-10, 219,5.783870e-10, 220,8.459851e-10, 221,9.545613e-10, 222,8.509963e-10, 223,5.055323e-10, 224,1.215849e-09,
+ 225,1.224856e-09, 226,3.231754e-10, 227,5.342097e-10, 228,8.083886e-10, 229,8.297442e-10, 230,1.020145e-09, 231,2.881686e-10, 232,4.809909e-10,
+ 233,9.967950e-10, 234,3.183281e-10, 235,6.030814e-10, 236,7.163857e-10, 237,1.209101e-09, 238,6.470948e-10, 239,5.206585e-10, 240,3.357150e-10,
+ 241,7.392580e-10, 242,9.805567e-10, 243,1.140986e-09, 244,5.543263e-10, 245,9.686764e-10, 246,4.490255e-10, 247,8.287710e-10, 248,9.082418e-10,
+ 249,1.279720e-09, 250,5.751107e-10, 251,8.926899e-10, 252,5.000991e-10, 253,1.299287e-09, 254,2.693699e-10, 255,1.299287e-09, 256,1.299287e-09,
+ 257,2.693699e-10, 258,1.299287e-09, 259,1.299287e-09)
.param C3Cpad=table(run, 1,3.489749e-13, 2,3.489749e-13, 3,2.876594e-13, 4,3.689556e-13, 5,3.910937e-13, 6,3.418711e-13, 7,4.155991e-13, 8,3.500608e-13,
+ 9,3.060372e-13, 10,3.097843e-13, 11,3.668297e-13, 12,4.420664e-13, 13,5.054748e-13, 14,2.779844e-13, 15,3.701696e-13, 16,2.102219e-13,
+ 17,2.526155e-13, 18,3.445115e-13, 19,4.648825e-13, 20,4.797934e-13, 21,1.828033e-13, 22,4.666710e-13, 23,3.852258e-13, 24,2.953894e-13,
+ 25,5.127586e-13, 26,5.000223e-13, 27,3.378174e-13, 28,4.740775e-13, 29,2.492827e-13, 30,2.009618e-13, 31,2.565877e-13, 32,2.631329e-13,
+ 33,4.304539e-13, 34,3.675159e-13, 35,3.687085e-13, 36,4.351367e-13, 37,4.121203e-13, 38,3.352094e-13, 39,4.013902e-13, 40,2.300965e-13,
+ 41,4.736997e-13, 42,4.955156e-13, 43,2.233661e-13, 44,2.544231e-13, 45,3.247951e-13, 46,4.563496e-13, 47,1.983239e-13, 48,4.961671e-13,
+ 49,4.574455e-13, 50,4.680318e-13, 51,3.274294e-13, 52,3.874626e-13, 53,2.181153e-13, 54,1.740596e-13, 55,2.639725e-13, 56,3.729244e-13,
+ 57,3.312796e-13, 58,4.516913e-13, 59,2.689124e-13, 60,3.862351e-13, 61,2.142277e-13, 62,2.382244e-13, 63,5.174232e-13, 64,3.889757e-13,
+ 65,2.843395e-13, 66,4.864764e-13, 67,5.127113e-13, 68,2.377278e-13, 69,4.597495e-13, 70,4.400319e-13, 71,3.128522e-13, 72,5.223835e-13,
+ 73,3.906295e-13, 74,3.491437e-13, 75,4.362019e-13, 76,4.554495e-13, 77,2.903896e-13, 78,2.974403e-13, 79,3.401289e-13, 80,2.560372e-13,
+ 81,4.240767e-13, 82,2.646420e-13, 83,2.089994e-13, 84,3.433288e-13, 85,3.241368e-13, 86,2.856646e-13, 87,3.265349e-13, 88,1.701729e-13,
+ 89,2.661963e-13, 90,5.155370e-13, 91,3.752067e-13, 92,2.780779e-13, 93,2.129640e-13, 94,2.991699e-13, 95,1.946182e-13, 96,3.343448e-13,
+ 97,1.998482e-13, 98,2.987446e-13, 99,2.649684e-13, 100,4.952768e-13, 101,3.335311e-13, 102,4.998426e-13, 103,3.680441e-13, 104,2.549305e-13,
+ 105,4.241859e-13, 106,1.777024e-13, 107,2.593642e-13, 108,3.850008e-13, 109,3.519305e-13, 110,3.605066e-13, 111,2.130315e-13, 112,4.759179e-13,
+ 113,1.930222e-13, 114,4.595956e-13, 115,4.579705e-13, 116,4.769506e-13, 117,2.092255e-13, 118,3.361392e-13, 119,4.105983e-13, 120,2.828484e-13,
+ 121,3.248793e-13, 122,3.646474e-13, 123,2.707920e-13, 124,4.914537e-13, 125,2.157734e-13, 126,1.761670e-13, 127,4.834477e-13, 128,4.275131e-13,
+ 129,3.032648e-13, 130,5.170679e-13, 131,4.818530e-13, 132,4.552712e-13, 133,4.756389e-13, 134,3.053599e-13, 135,2.141153e-13, 136,5.239415e-13,
+ 137,4.170674e-13, 138,4.140752e-13, 139,2.152114e-13, 140,3.797893e-13, 141,1.808933e-13, 142,3.420317e-13, 143,4.136570e-13, 144,2.910157e-13,
+ 145,2.731746e-13, 146,1.996698e-13, 147,3.009943e-13, 148,4.704128e-13, 149,4.143759e-13, 150,1.875510e-13, 151,4.917540e-13, 152,3.893934e-13,
+ 153,4.025788e-13, 154,4.802666e-13, 155,3.325656e-13, 156,3.624889e-13, 157,4.818042e-13, 158,2.747672e-13, 159,5.013338e-13, 160,3.768042e-13,
+ 161,4.828020e-13, 162,4.409827e-13, 163,3.079752e-13, 164,1.738125e-13, 165,4.868074e-13, 166,3.253277e-13, 167,4.225753e-13, 168,4.345654e-13,
+ 169,1.979999e-13, 170,3.188903e-13, 171,3.456048e-13, 172,3.305768e-13, 173,1.762669e-13, 174,3.375599e-13, 175,5.160034e-13, 176,2.698054e-13,
+ 177,2.620014e-13, 178,4.997815e-13, 179,5.083710e-13, 180,4.070662e-13, 181,2.776153e-13, 182,4.479171e-13, 183,5.254512e-13, 184,3.882437e-13,
+ 185,1.761372e-13, 186,3.863162e-13, 187,4.666848e-13, 188,2.385517e-13, 189,2.798429e-13, 190,4.835436e-13, 191,1.829948e-13, 192,5.173626e-13,
+ 193,1.902435e-13, 194,3.850709e-13, 195,4.122748e-13, 196,4.675270e-13, 197,4.784728e-13, 198,5.053699e-13, 199,2.106631e-13, 200,3.440701e-13,
+ 201,4.106143e-13, 202,2.001371e-13, 203,2.834412e-13, 204,3.498194e-13, 205,2.564934e-13, 206,2.392474e-13, 207,4.680979e-13, 208,2.704113e-13,
+ 209,4.347626e-13, 210,4.841495e-13, 211,3.642849e-13, 212,1.749000e-13, 213,2.245224e-13, 214,2.083990e-13, 215,2.475659e-13, 216,5.199131e-13,
+ 217,3.743703e-13, 218,3.075521e-13, 219,2.548977e-13, 220,1.792169e-13, 221,3.735379e-13, 222,2.765262e-13, 223,3.481302e-13, 224,5.261465e-13,
+ 225,5.205646e-13, 226,4.421396e-13, 227,2.107872e-13, 228,2.577695e-13, 229,4.742306e-13, 230,4.420047e-13, 231,2.393250e-13, 232,5.244043e-13,
+ 233,3.047145e-13, 234,4.138840e-13, 235,4.026043e-13, 236,3.699137e-13, 237,2.330924e-13, 238,2.243197e-13, 239,2.038450e-13, 240,2.152188e-13,
+ 241,2.530031e-13, 242,5.211930e-13, 243,5.060671e-13, 244,3.347598e-13, 245,3.013177e-13, 246,2.133419e-13, 247,4.275477e-13, 248,2.945438e-13,
+ 249,3.983087e-13, 250,4.963817e-13, 251,2.565790e-13, 252,3.660216e-13, 253,5.296728e-13, 254,1.682769e-13, 255,5.296728e-13, 256,5.296728e-13,
+ 257,1.682769e-13, 258,5.296728e-13, 259,5.296728e-13)
.param C5C=table(run, 1,3.822000e-11, 2,3.978000e-11, 3,3.932787e-11, 4,3.910126e-11, 5,3.888725e-11, 6,3.969276e-11, 7,3.845265e-11, 8,3.862963e-11,
+ 9,3.914292e-11, 10,3.929757e-11, 11,3.873258e-11, 12,3.894517e-11, 13,3.920499e-11, 14,3.897192e-11, 15,3.945038e-11, 16,3.856801e-11,
+ 17,3.880912e-11, 18,3.836547e-11, 19,3.840957e-11, 20,3.876024e-11, 21,3.875947e-11, 22,3.957417e-11, 23,3.953633e-11, 24,3.854082e-11,
+ 25,3.940111e-11, 26,3.885746e-11, 27,3.831215e-11, 28,3.969302e-11, 29,3.920088e-11, 30,3.911086e-11, 31,3.825144e-11, 32,3.901746e-11,
+ 33,3.869037e-11, 34,3.961881e-11, 35,3.893945e-11, 36,3.889802e-11, 37,3.874310e-11, 38,3.950680e-11, 39,3.938339e-11, 40,3.957879e-11,
+ 41,3.967237e-11, 42,3.940082e-11, 43,3.857075e-11, 44,3.831658e-11, 45,3.971366e-11, 46,3.896220e-11, 47,3.966867e-11, 48,3.908793e-11,
+ 49,3.977833e-11, 50,3.893989e-11, 51,3.942773e-11, 52,3.898330e-11, 53,3.957377e-11, 54,3.916247e-11, 55,3.823006e-11, 56,3.886913e-11,
+ 57,3.853237e-11, 58,3.954661e-11, 59,3.900016e-11, 60,3.964558e-11, 61,3.846391e-11, 62,3.965645e-11, 63,3.864064e-11, 64,3.966866e-11,
+ 65,3.893040e-11, 66,3.944739e-11, 67,3.869843e-11, 68,3.863181e-11, 69,3.946411e-11, 70,3.911755e-11, 71,3.974469e-11, 72,3.869725e-11,
+ 73,3.834289e-11, 74,3.889183e-11, 75,3.953485e-11, 76,3.889331e-11, 77,3.942084e-11, 78,3.967018e-11, 79,3.847866e-11, 80,3.865086e-11,
+ 81,3.842399e-11, 82,3.847556e-11, 83,3.845205e-11, 84,3.967210e-11, 85,3.894769e-11, 86,3.927631e-11, 87,3.849128e-11, 88,3.973058e-11,
+ 89,3.832767e-11, 90,3.971495e-11, 91,3.898282e-11, 92,3.965077e-11, 93,3.910703e-11, 94,3.861622e-11, 95,3.957154e-11, 96,3.914601e-11,
+ 97,3.829761e-11, 98,3.839605e-11, 99,3.922308e-11, 100,3.937632e-11, 101,3.934778e-11, 102,3.841754e-11, 103,3.964067e-11, 104,3.918173e-11,
+ 105,3.847122e-11, 106,3.913249e-11, 107,3.832454e-11, 108,3.927259e-11, 109,3.967514e-11, 110,3.860335e-11, 111,3.964573e-11, 112,3.854117e-11,
+ 113,3.917661e-11, 114,3.922538e-11, 115,3.824543e-11, 116,3.838877e-11, 117,3.827537e-11, 118,3.948790e-11, 119,3.879231e-11, 120,3.919538e-11,
+ 121,3.965043e-11, 122,3.916796e-11, 123,3.850315e-11, 124,3.920479e-11, 125,3.904642e-11, 126,3.832419e-11, 127,3.877350e-11, 128,3.858899e-11,
+ 129,3.919912e-11, 130,3.831964e-11, 131,3.859000e-11, 132,3.901647e-11, 133,3.897943e-11, 134,3.919773e-11, 135,3.884048e-11, 136,3.865913e-11,
+ 137,3.882532e-11, 138,3.822968e-11, 139,3.832810e-11, 140,3.928947e-11, 141,3.950253e-11, 142,3.972727e-11, 143,3.827871e-11, 144,3.848755e-11,
+ 145,3.825744e-11, 146,3.905029e-11, 147,3.867888e-11, 148,3.833789e-11, 149,3.938979e-11, 150,3.921884e-11, 151,3.824045e-11, 152,3.942493e-11,
+ 153,3.914916e-11, 154,3.961304e-11, 155,3.936738e-11, 156,3.854146e-11, 157,3.862130e-11, 158,3.922576e-11, 159,3.941211e-11, 160,3.970454e-11,
+ 161,3.926814e-11, 162,3.879012e-11, 163,3.936566e-11, 164,3.929426e-11, 165,3.916687e-11, 166,3.840846e-11, 167,3.830847e-11, 168,3.834435e-11,
+ 169,3.853592e-11, 170,3.965355e-11, 171,3.825712e-11, 172,3.894179e-11, 173,3.890184e-11, 174,3.903425e-11, 175,3.942073e-11, 176,3.896758e-11,
+ 177,3.916064e-11, 178,3.891135e-11, 179,3.919528e-11, 180,3.920301e-11, 181,3.925695e-11, 182,3.875071e-11, 183,3.852619e-11, 184,3.958350e-11,
+ 185,3.892433e-11, 186,3.904864e-11, 187,3.947584e-11, 188,3.907708e-11, 189,3.866344e-11, 190,3.971416e-11, 191,3.850048e-11, 192,3.927833e-11,
+ 193,3.825257e-11, 194,3.881001e-11, 195,3.828111e-11, 196,3.901556e-11, 197,3.952964e-11, 198,3.883080e-11, 199,3.880053e-11, 200,3.837562e-11,
+ 201,3.950376e-11, 202,3.944301e-11, 203,3.889602e-11, 204,3.852541e-11, 205,3.844131e-11, 206,3.887361e-11, 207,3.924418e-11, 208,3.837909e-11,
+ 209,3.941355e-11, 210,3.926429e-11, 211,3.930997e-11, 212,3.957548e-11, 213,3.891282e-11, 214,3.872921e-11, 215,3.925795e-11, 216,3.937771e-11,
+ 217,3.969416e-11, 218,3.969030e-11, 219,3.875308e-11, 220,3.957365e-11, 221,3.826068e-11, 222,3.873537e-11, 223,3.925274e-11, 224,3.825174e-11,
+ 225,3.962280e-11, 226,3.899020e-11, 227,3.868306e-11, 228,3.951173e-11, 229,3.955445e-11, 230,3.971270e-11, 231,3.937257e-11, 232,3.929554e-11,
+ 233,3.951156e-11, 234,3.856968e-11, 235,3.872388e-11, 236,3.906418e-11, 237,3.832010e-11, 238,3.837939e-11, 239,3.830113e-11, 240,3.934767e-11,
+ 241,3.892579e-11, 242,3.852812e-11, 243,3.842724e-11, 244,3.833480e-11, 245,3.923708e-11, 246,3.872518e-11, 247,3.870474e-11, 248,3.895616e-11,
+ 249,3.843449e-11, 250,3.966716e-11, 251,3.881336e-11, 252,3.877374e-11, 253,3.978000e-11, 254,3.822000e-11, 255,3.822000e-11, 256,3.978000e-11,
+ 257,3.822000e-11, 258,3.978000e-11, 259,3.978000e-11)
.param C5ESR=table(run, 1,2.000000e-01, 2,2.000000e-01, 3,3.870949e-01, 4,3.862028e-01, 5,3.808255e-01, 6,2.334807e-01, 7,1.664153e-01, 8,1.775138e-01,
+ 9,1.932378e-01, 10,3.658144e-01, 11,3.955389e-01, 12,1.942332e-01, 13,2.851831e-01, 14,3.710661e-01, 15,3.592772e-01, 16,2.431319e-01,
+ 17,1.863439e-01, 18,2.035105e-01, 19,3.227707e-01, 20,1.986528e-01, 21,1.834075e-01, 22,3.991802e-01, 23,3.157013e-01, 24,1.800613e-01,
+ 25,1.014208e-01, 26,1.904612e-01, 27,2.322779e-01, 28,1.938282e-01, 29,1.712304e-01, 30,2.334683e-01, 31,2.183727e-01, 32,1.310268e-01,
+ 33,1.264210e-01, 34,3.332733e-01, 35,3.701673e-01, 36,3.074416e-01, 37,3.855812e-01, 38,1.743513e-01, 39,2.888895e-01, 40,2.919621e-01,
+ 41,1.711603e-01, 42,1.033624e-01, 43,2.835094e-01, 44,3.034238e-01, 45,3.325359e-01, 46,3.667616e-01, 47,2.229496e-01, 48,2.410382e-01,
+ 49,1.863258e-01, 50,3.492024e-01, 51,2.301754e-01, 52,1.637036e-01, 53,2.853448e-01, 54,2.586167e-01, 55,3.788929e-01, 56,2.908172e-01,
+ 57,3.827128e-01, 58,2.029931e-01, 59,2.644988e-01, 60,1.324287e-01, 61,3.425900e-01, 62,3.870769e-01, 63,2.670494e-01, 64,3.025093e-01,
+ 65,2.423066e-01, 66,2.937044e-01, 67,2.131731e-01, 68,2.263953e-01, 69,2.520823e-01, 70,3.331495e-01, 71,3.666662e-01, 72,3.893254e-01,
+ 73,3.787144e-01, 74,2.478060e-01, 75,1.408128e-01, 76,1.409510e-01, 77,1.538861e-01, 78,3.845191e-01, 79,1.561584e-01, 80,3.942796e-01,
+ 81,1.687022e-01, 82,1.397071e-01, 83,2.819443e-01, 84,1.882790e-01, 85,1.160200e-01, 86,3.484591e-01, 87,1.849438e-01, 88,1.417487e-01,
+ 89,2.532128e-01, 90,1.551072e-01, 91,1.572160e-01, 92,2.063843e-01, 93,2.950739e-01, 94,3.905599e-01, 95,1.074287e-01, 96,3.794542e-01,
+ 97,3.381515e-01, 98,2.492720e-01, 99,3.957737e-01, 100,3.533325e-01, 101,3.216827e-01, 102,2.262539e-01, 103,2.640051e-01, 104,2.935714e-01,
+ 105,3.234119e-01, 106,3.917975e-01, 107,3.889577e-01, 108,1.370646e-01, 109,3.081403e-01, 110,1.712295e-01, 111,3.893047e-01, 112,1.758073e-01,
+ 113,2.819870e-01, 114,1.313541e-01, 115,2.221938e-01, 116,2.234087e-01, 117,1.378223e-01, 118,1.367465e-01, 119,3.088491e-01, 120,1.350111e-01,
+ 121,3.995562e-01, 122,3.619161e-01, 123,1.638228e-01, 124,3.629313e-01, 125,1.047381e-01, 126,3.994452e-01, 127,1.577324e-01, 128,1.951794e-01,
+ 129,3.692896e-01, 130,3.299443e-01, 131,3.618320e-01, 132,3.226179e-01, 133,1.190387e-01, 134,2.987374e-01, 135,2.702762e-01, 136,1.879224e-01,
+ 137,3.563241e-01, 138,1.502908e-01, 139,3.839947e-01, 140,3.432307e-01, 141,3.771566e-01, 142,2.898090e-01, 143,1.051269e-01, 144,1.456224e-01,
+ 145,2.589952e-01, 146,3.936384e-01, 147,3.444723e-01, 148,1.568444e-01, 149,3.411823e-01, 150,3.035519e-01, 151,3.590356e-01, 152,3.272520e-01,
+ 153,2.516453e-01, 154,2.672218e-01, 155,1.635447e-01, 156,2.816677e-01, 157,1.144573e-01, 158,3.945445e-01, 159,2.965511e-01, 160,3.911728e-01,
+ 161,2.357695e-01, 162,2.678704e-01, 163,2.063861e-01, 164,1.587577e-01, 165,1.908329e-01, 166,1.854234e-01, 167,1.697590e-01, 168,1.253546e-01,
+ 169,3.215606e-01, 170,1.305900e-01, 171,1.600574e-01, 172,3.118619e-01, 173,2.641089e-01, 174,1.225448e-01, 175,2.347666e-01, 176,1.862252e-01,
+ 177,1.262319e-01, 178,3.032127e-01, 179,2.032888e-01, 180,2.838478e-01, 181,3.703690e-01, 182,2.811003e-01, 183,1.487053e-01, 184,3.685339e-01,
+ 185,3.149360e-01, 186,1.441333e-01, 187,2.170582e-01, 188,1.762157e-01, 189,1.864790e-01, 190,3.121840e-01, 191,3.899810e-01, 192,1.541330e-01,
+ 193,1.070637e-01, 194,1.430932e-01, 195,3.639318e-01, 196,1.565100e-01, 197,3.111757e-01, 198,2.498568e-01, 199,3.082759e-01, 200,1.214731e-01,
+ 201,3.647459e-01, 202,3.650756e-01, 203,2.462385e-01, 204,1.802095e-01, 205,1.509491e-01, 206,2.926221e-01, 207,1.402352e-01, 208,3.491737e-01,
+ 209,2.948177e-01, 210,3.702530e-01, 211,2.218381e-01, 212,1.955822e-01, 213,2.110033e-01, 214,1.847034e-01, 215,3.601989e-01, 216,3.126038e-01,
+ 217,3.682048e-01, 218,1.198780e-01, 219,1.973919e-01, 220,1.143297e-01, 221,2.209761e-01, 222,1.779010e-01, 223,3.430978e-01, 224,1.708868e-01,
+ 225,1.077820e-01, 226,2.609783e-01, 227,1.465104e-01, 228,2.076993e-01, 229,1.194347e-01, 230,1.903588e-01, 231,2.045715e-01, 232,1.286530e-01,
+ 233,3.141852e-01, 234,1.233797e-01, 235,2.788211e-01, 236,3.536024e-01, 237,1.681164e-01, 238,3.127893e-01, 239,2.912342e-01, 240,1.308108e-01,
+ 241,3.640766e-01, 242,2.015645e-01, 243,3.549900e-01, 244,3.866456e-01, 245,1.136204e-01, 246,2.266595e-01, 247,2.815078e-01, 248,2.216262e-01,
+ 249,3.331875e-01, 250,3.916656e-01, 251,3.776558e-01, 252,2.410830e-01, 253,4.000000e-01, 254,1.000000e-01, 255,4.000000e-01, 256,1.000000e-01,
+ 257,4.000000e-01, 258,4.000000e-01, 259,4.000000e-01)
.param C5ESL=table(run, 1,1.000000e-09, 2,1.000000e-09, 3,8.517631e-10, 4,6.058602e-10, 5,9.313407e-10, 6,7.063340e-10, 7,1.139552e-09, 8,6.978603e-10,
+ 9,1.058165e-09, 10,9.837715e-10, 11,8.205542e-10, 12,8.557584e-10, 13,9.728411e-10, 14,1.155425e-09, 15,8.677074e-10, 16,6.506209e-10,
+ 17,6.246695e-10, 18,9.392511e-10, 19,9.691634e-10, 20,9.830023e-10, 21,6.403689e-10, 22,1.153609e-09, 23,6.818799e-10, 24,1.000586e-09,
+ 25,7.409388e-10, 26,1.019176e-09, 27,1.180990e-09, 28,9.744337e-10, 29,1.026054e-09, 30,1.197323e-09, 31,1.049528e-09, 32,6.674363e-10,
+ 33,9.058813e-10, 34,7.024315e-10, 35,8.262308e-10, 36,1.003016e-09, 37,8.375684e-10, 38,9.014057e-10, 39,1.173629e-09, 40,1.162444e-09,
+ 41,6.713301e-10, 42,8.625471e-10, 43,7.081868e-10, 44,6.339231e-10, 45,6.924758e-10, 46,7.870846e-10, 47,6.481829e-10, 48,8.246484e-10,
+ 49,1.090170e-09, 50,1.193489e-09, 51,8.455233e-10, 52,6.420904e-10, 53,1.032932e-09, 54,7.862182e-10, 55,1.115474e-09, 56,1.163897e-09,
+ 57,6.870205e-10, 58,7.903073e-10, 59,9.244411e-10, 60,9.900989e-10, 61,6.528245e-10, 62,6.901994e-10, 63,1.016483e-09, 64,1.152299e-09,
+ 65,7.534223e-10, 66,7.679281e-10, 67,8.447220e-10, 68,1.157818e-09, 69,1.023558e-09, 70,1.128604e-09, 71,8.092597e-10, 72,7.074058e-10,
+ 73,6.619284e-10, 74,1.077831e-09, 75,9.598822e-10, 76,8.464554e-10, 77,6.694544e-10, 78,1.051151e-09, 79,9.957252e-10, 80,6.040542e-10,
+ 81,7.078054e-10, 82,6.599849e-10, 83,7.654967e-10, 84,1.177932e-09, 85,7.850316e-10, 86,6.323676e-10, 87,6.036246e-10, 88,9.833072e-10,
+ 89,7.037947e-10, 90,8.828195e-10, 91,1.127050e-09, 92,1.179533e-09, 93,9.548876e-10, 94,7.136340e-10, 95,9.515713e-10, 96,1.093925e-09,
+ 97,8.533872e-10, 98,1.108325e-09, 99,1.127698e-09, 100,1.177923e-09, 101,1.129474e-09, 102,7.782688e-10, 103,7.818956e-10, 104,6.080965e-10,
+ 105,8.166392e-10, 106,8.509108e-10, 107,9.356483e-10, 108,9.491169e-10, 109,7.670684e-10, 110,9.757410e-10, 111,1.042760e-09, 112,8.941935e-10,
+ 113,1.063281e-09, 114,8.804005e-10, 115,6.532881e-10, 116,7.012236e-10, 117,1.177650e-09, 118,9.637986e-10, 119,1.127618e-09, 120,1.185738e-09,
+ 121,1.115276e-09, 122,1.122024e-09, 123,1.106604e-09, 124,1.102356e-09, 125,8.573961e-10, 126,1.162069e-09, 127,1.145231e-09, 128,7.341141e-10,
+ 129,6.677500e-10, 130,1.087626e-09, 131,8.838491e-10, 132,1.105838e-09, 133,1.020419e-09, 134,1.163933e-09, 135,7.952926e-10, 136,8.957359e-10,
+ 137,1.139630e-09, 138,1.075861e-09, 139,9.682106e-10, 140,8.222865e-10, 141,1.162226e-09, 142,8.906362e-10, 143,8.220982e-10, 144,1.099377e-09,
+ 145,8.346013e-10, 146,6.397957e-10, 147,8.503000e-10, 148,9.686420e-10, 149,1.137068e-09, 150,8.512996e-10, 151,6.975744e-10, 152,6.167954e-10,
+ 153,7.504956e-10, 154,1.011266e-09, 155,9.430714e-10, 156,1.117266e-09, 157,1.055847e-09, 158,8.363443e-10, 159,8.463518e-10, 160,9.756123e-10,
+ 161,1.136738e-09, 162,9.292606e-10, 163,1.106419e-09, 164,1.010799e-09, 165,9.146781e-10, 166,1.063538e-09, 167,6.916141e-10, 168,7.217748e-10,
+ 169,1.024319e-09, 170,7.632821e-10, 171,7.900313e-10, 172,6.668407e-10, 173,7.885211e-10, 174,1.045354e-09, 175,1.060054e-09, 176,1.142551e-09,
+ 177,1.161355e-09, 178,1.167780e-09, 179,8.747578e-10, 180,6.677164e-10, 181,6.169193e-10, 182,9.520380e-10, 183,1.066371e-09, 184,1.185275e-09,
+ 185,1.154152e-09, 186,7.381872e-10, 187,6.803177e-10, 188,6.900782e-10, 189,9.302174e-10, 190,7.002584e-10, 191,1.043149e-09, 192,1.186681e-09,
+ 193,7.164465e-10, 194,9.097546e-10, 195,7.090774e-10, 196,6.517995e-10, 197,7.371088e-10, 198,8.625199e-10, 199,8.998986e-10, 200,9.996676e-10,
+ 201,1.123982e-09, 202,1.073711e-09, 203,1.171838e-09, 204,1.042864e-09, 205,9.051474e-10, 206,1.164959e-09, 207,1.164549e-09, 208,6.993004e-10,
+ 209,9.029696e-10, 210,6.150010e-10, 211,1.040778e-09, 212,1.146297e-09, 213,7.982177e-10, 214,1.127310e-09, 215,7.658536e-10, 216,8.607141e-10,
+ 217,6.095764e-10, 218,6.825297e-10, 219,1.041795e-09, 220,6.719802e-10, 221,9.570355e-10, 222,8.876887e-10, 223,7.073738e-10, 224,1.172061e-09,
+ 225,9.905071e-10, 226,7.575425e-10, 227,7.224664e-10, 228,7.615020e-10, 229,9.051763e-10, 230,1.085277e-09, 231,1.032747e-09, 232,9.238310e-10,
+ 233,8.134768e-10, 234,9.757988e-10, 235,9.016778e-10, 236,1.031819e-09, 237,1.048782e-09, 238,6.952904e-10, 239,9.672883e-10, 240,1.125643e-09,
+ 241,1.084413e-09, 242,1.182570e-09, 243,1.086437e-09, 244,9.439265e-10, 245,7.729214e-10, 246,8.862046e-10, 247,9.497766e-10, 248,8.841266e-10,
+ 249,8.758806e-10, 250,8.391547e-10, 251,7.116073e-10, 252,8.296652e-10, 253,1.200000e-09, 254,6.000000e-10, 255,6.000000e-10, 256,1.200000e-09,
+ 257,6.000000e-10, 258,1.200000e-09, 259,1.200000e-09)
.param C5Lvia=table(run, 1,8.496433e-10, 2,8.496433e-10, 3,1.154522e-09, 4,5.458244e-10, 5,6.489792e-10, 6,1.243352e-09, 7,4.895241e-10, 8,4.637557e-10,
+ 9,1.130807e-09, 10,1.091579e-09, 11,7.708515e-10, 12,1.247852e-09, 13,4.535020e-10, 14,3.917939e-10, 15,3.408969e-10, 16,9.687997e-10,
+ 17,1.194417e-09, 18,4.472731e-10, 19,4.196249e-10, 20,1.233357e-09, 21,8.579541e-10, 22,1.032799e-09, 23,7.631418e-10, 24,8.096914e-10,
+ 25,5.383402e-10, 26,1.068479e-09, 27,1.252928e-09, 28,1.041034e-09, 29,9.370532e-10, 30,1.170181e-09, 31,1.013110e-09, 32,6.400021e-10,
+ 33,3.652610e-10, 34,1.020483e-09, 35,4.967689e-10, 36,7.006559e-10, 37,3.348687e-10, 38,1.107811e-09, 39,8.948599e-10, 40,7.459870e-10,
+ 41,1.146766e-09, 42,4.262485e-10, 43,4.385805e-10, 44,1.008605e-09, 45,3.437143e-10, 46,4.689173e-10, 47,9.583772e-10, 48,7.505012e-10,
+ 49,7.229687e-10, 50,4.728861e-10, 51,5.580741e-10, 52,6.797468e-10, 53,1.032985e-09, 54,8.476282e-10, 55,1.011861e-09, 56,4.595458e-10,
+ 57,8.502074e-10, 58,1.258149e-09, 59,3.956391e-10, 60,4.363445e-10, 61,6.868816e-10, 62,7.956175e-10, 63,9.751832e-10, 64,8.782827e-10,
+ 65,3.143686e-10, 66,3.843437e-10, 67,4.472756e-10, 68,4.407034e-10, 69,9.102238e-10, 70,1.272000e-09, 71,1.029935e-09, 72,5.289308e-10,
+ 73,6.538512e-10, 74,5.312574e-10, 75,1.090157e-09, 76,9.011760e-10, 77,3.964151e-10, 78,1.020925e-09, 79,3.725750e-10, 80,5.292007e-10,
+ 81,5.770242e-10, 82,4.125331e-10, 83,6.701822e-10, 84,3.263810e-10, 85,9.146825e-10, 86,3.450321e-10, 87,1.288330e-09, 88,4.321795e-10,
+ 89,9.979626e-10, 90,3.414943e-10, 91,1.133744e-09, 92,4.459779e-10, 93,1.210314e-09, 94,7.115432e-10, 95,9.162056e-10, 96,9.318151e-10,
+ 97,1.017680e-09, 98,3.945927e-10, 99,4.733234e-10, 100,9.422253e-10, 101,8.460215e-10, 102,6.992925e-10, 103,7.692510e-10, 104,1.208655e-09,
+ 105,1.006519e-09, 106,1.092621e-09, 107,1.102164e-09, 108,2.794301e-10, 109,2.910656e-10, 110,3.353422e-10, 111,5.708172e-10, 112,3.498453e-10,
+ 113,1.139279e-09, 114,1.217708e-09, 115,5.389142e-10, 116,1.104010e-09, 117,4.674814e-10, 118,1.160332e-09, 119,7.343814e-10, 120,5.336287e-10,
+ 121,8.164603e-10, 122,4.016166e-10, 123,7.436347e-10, 124,5.471665e-10, 125,2.723046e-10, 126,8.680579e-10, 127,9.910312e-10, 128,1.115639e-09,
+ 129,9.300084e-10, 130,7.616591e-10, 131,9.616858e-10, 132,6.366275e-10, 133,9.930013e-10, 134,1.211451e-09, 135,9.119226e-10, 136,8.806784e-10,
+ 137,1.084957e-09, 138,9.615365e-10, 139,1.151047e-09, 140,2.949085e-10, 141,8.728593e-10, 142,1.229637e-09, 143,1.102553e-09, 144,1.083559e-09,
+ 145,4.725148e-10, 146,6.990690e-10, 147,1.030764e-09, 148,1.109203e-09, 149,1.146620e-09, 150,1.084662e-09, 151,1.272363e-09, 152,1.076258e-09,
+ 153,7.824171e-10, 154,6.368673e-10, 155,1.095936e-09, 156,6.271215e-10, 157,7.776677e-10, 158,9.374620e-10, 159,4.715692e-10, 160,6.405856e-10,
+ 161,3.231576e-10, 162,7.457618e-10, 163,7.577983e-10, 164,9.518876e-10, 165,6.098805e-10, 166,1.202843e-09, 167,8.588368e-10, 168,1.167618e-09,
+ 169,7.910200e-10, 170,1.161920e-09, 171,1.240034e-09, 172,7.227372e-10, 173,1.121062e-09, 174,1.083637e-09, 175,7.892149e-10, 176,1.238863e-09,
+ 177,1.007957e-09, 178,2.795900e-10, 179,1.005460e-09, 180,1.138702e-09, 181,4.532840e-10, 182,1.189911e-09, 183,1.018612e-09, 184,7.715900e-10,
+ 185,1.092182e-09, 186,7.441960e-10, 187,8.566344e-10, 188,8.735765e-10, 189,7.246037e-10, 190,5.406436e-10, 191,4.358695e-10, 192,4.169676e-10,
+ 193,1.275957e-09, 194,9.470341e-10, 195,7.762619e-10, 196,1.143622e-09, 197,7.926258e-10, 198,3.388565e-10, 199,3.318161e-10, 200,4.375253e-10,
+ 201,7.090590e-10, 202,8.509322e-10, 203,2.934547e-10, 204,3.542435e-10, 205,4.381306e-10, 206,4.521975e-10, 207,1.199835e-09, 208,1.156893e-09,
+ 209,1.045580e-09, 210,1.126560e-09, 211,4.387488e-10, 212,1.237665e-09, 213,8.176722e-10, 214,9.464168e-10, 215,8.661276e-10, 216,5.642712e-10,
+ 217,5.709751e-10, 218,7.331356e-10, 219,4.735496e-10, 220,9.280275e-10, 221,3.505224e-10, 222,1.041932e-09, 223,1.219593e-09, 224,7.403579e-10,
+ 225,1.003451e-09, 226,3.585458e-10, 227,5.497918e-10, 228,1.274338e-09, 229,6.055286e-10, 230,7.566449e-10, 231,7.400661e-10, 232,9.058587e-10,
+ 233,5.880508e-10, 234,1.106440e-09, 235,5.294891e-10, 236,4.528606e-10, 237,4.540990e-10, 238,1.134286e-09, 239,8.534810e-10, 240,6.566215e-10,
+ 241,2.746773e-10, 242,8.184550e-10, 243,8.587862e-10, 244,1.205819e-09, 245,7.916344e-10, 246,6.097042e-10, 247,5.073206e-10, 248,5.506066e-10,
+ 249,3.458113e-10, 250,4.446035e-10, 251,3.993305e-10, 252,6.717790e-10, 253,1.299287e-09, 254,2.693699e-10, 255,2.693699e-10, 256,1.299287e-09,
+ 257,2.693699e-10, 258,1.299287e-09, 259,1.299287e-09)
.param C5Cpad=table(run, 1,3.489749e-13, 2,3.489749e-13, 3,1.772582e-13, 4,3.250892e-13, 5,4.885461e-13, 6,2.583271e-13, 7,1.754381e-13, 8,1.699797e-13,
+ 9,2.796471e-13, 10,4.400360e-13, 11,3.195103e-13, 12,3.834546e-13, 13,3.705019e-13, 14,3.225587e-13, 15,3.896040e-13, 16,3.120158e-13,
+ 17,3.158763e-13, 18,2.436906e-13, 19,4.722510e-13, 20,1.794445e-13, 21,2.590033e-13, 22,2.073545e-13, 23,2.136237e-13, 24,4.391763e-13,
+ 25,4.583052e-13, 26,2.466792e-13, 27,4.691581e-13, 28,2.595071e-13, 29,2.271474e-13, 30,4.983000e-13, 31,3.857242e-13, 32,2.158332e-13,
+ 33,2.009132e-13, 34,4.252639e-13, 35,3.918276e-13, 36,3.455182e-13, 37,2.412691e-13, 38,4.299652e-13, 39,4.415112e-13, 40,3.922563e-13,
+ 41,3.127639e-13, 42,2.385995e-13, 43,4.665541e-13, 44,2.787912e-13, 45,4.099726e-13, 46,2.230962e-13, 47,5.217785e-13, 48,3.311291e-13,
+ 49,2.484452e-13, 50,4.516189e-13, 51,4.102916e-13, 52,2.871133e-13, 53,3.831353e-13, 54,1.718477e-13, 55,3.942756e-13, 56,3.348061e-13,
+ 57,4.070165e-13, 58,5.063666e-13, 59,1.995359e-13, 60,4.652263e-13, 61,3.344641e-13, 62,4.376906e-13, 63,2.964181e-13, 64,4.057591e-13,
+ 65,5.248887e-13, 66,5.267852e-13, 67,2.034685e-13, 68,3.603259e-13, 69,4.221429e-13, 70,2.014448e-13, 71,1.985903e-13, 72,3.364536e-13,
+ 73,2.304677e-13, 74,5.253118e-13, 75,4.344198e-13, 76,5.176917e-13, 77,3.989378e-13, 78,2.455436e-13, 79,3.598712e-13, 80,2.843055e-13,
+ 81,4.425240e-13, 82,2.045129e-13, 83,2.051810e-13, 84,5.177289e-13, 85,3.712655e-13, 86,2.966602e-13, 87,3.977204e-13, 88,3.070012e-13,
+ 89,3.147716e-13, 90,4.994477e-13, 91,4.934657e-13, 92,4.591039e-13, 93,2.704767e-13, 94,4.261660e-13, 95,2.844978e-13, 96,4.341127e-13,
+ 97,3.197224e-13, 98,4.096686e-13, 99,4.515486e-13, 100,3.905554e-13, 101,4.700950e-13, 102,4.034281e-13, 103,2.393883e-13, 104,3.882404e-13,
+ 105,3.573052e-13, 106,2.368758e-13, 107,2.615867e-13, 108,2.890563e-13, 109,4.239497e-13, 110,4.063779e-13, 111,4.075858e-13, 112,4.331696e-13,
+ 113,2.945956e-13, 114,3.446923e-13, 115,2.724384e-13, 116,3.874778e-13, 117,2.563075e-13, 118,4.937825e-13, 119,4.091093e-13, 120,5.078339e-13,
+ 121,1.841831e-13, 122,4.193868e-13, 123,3.530618e-13, 124,1.918201e-13, 125,4.902385e-13, 126,3.161107e-13, 127,2.621269e-13, 128,4.732746e-13,
+ 129,2.390420e-13, 130,4.749689e-13, 131,4.096241e-13, 132,2.805361e-13, 133,2.552107e-13, 134,5.138094e-13, 135,2.113276e-13, 136,2.947041e-13,
+ 137,5.015535e-13, 138,2.329683e-13, 139,3.859050e-13, 140,4.832549e-13, 141,3.374730e-13, 142,5.212848e-13, 143,4.792892e-13, 144,4.159129e-13,
+ 145,2.540439e-13, 146,2.300521e-13, 147,1.817498e-13, 148,4.357340e-13, 149,4.997137e-13, 150,4.336767e-13, 151,2.252536e-13, 152,3.925124e-13,
+ 153,3.513171e-13, 154,2.701868e-13, 155,2.537609e-13, 156,2.910719e-13, 157,2.287349e-13, 158,5.250960e-13, 159,3.296665e-13, 160,3.173381e-13,
+ 161,3.915560e-13, 162,3.721570e-13, 163,5.088691e-13, 164,1.999785e-13, 165,3.785839e-13, 166,5.285691e-13, 167,2.043106e-13, 168,3.185789e-13,
+ 169,2.756505e-13, 170,4.774845e-13, 171,4.797717e-13, 172,3.151216e-13, 173,2.817697e-13, 174,2.478280e-13, 175,4.259044e-13, 176,3.910923e-13,
+ 177,4.155454e-13, 178,2.152940e-13, 179,3.821942e-13, 180,2.152770e-13, 181,3.705202e-13, 182,2.735790e-13, 183,2.599733e-13, 184,4.404465e-13,
+ 185,1.981398e-13, 186,2.237054e-13, 187,2.760597e-13, 188,3.953068e-13, 189,5.183272e-13, 190,4.650634e-13, 191,4.423153e-13, 192,3.674351e-13,
+ 193,4.592106e-13, 194,2.308186e-13, 195,2.777046e-13, 196,4.004270e-13, 197,4.377238e-13, 198,4.745446e-13, 199,2.167653e-13, 200,2.433951e-13,
+ 201,3.758204e-13, 202,4.571376e-13, 203,3.197622e-13, 204,2.423749e-13, 205,2.468925e-13, 206,5.062738e-13, 207,4.570939e-13, 208,2.253525e-13,
+ 209,2.917055e-13, 210,3.133865e-13, 211,2.404393e-13, 212,4.667308e-13, 213,5.184729e-13, 214,2.078998e-13, 215,3.228624e-13, 216,1.942991e-13,
+ 217,2.273365e-13, 218,2.544787e-13, 219,3.024993e-13, 220,4.313966e-13, 221,4.724859e-13, 222,3.497891e-13, 223,4.311155e-13, 224,2.743329e-13,
+ 225,3.523449e-13, 226,2.042738e-13, 227,3.347410e-13, 228,5.290605e-13, 229,2.140391e-13, 230,2.839805e-13, 231,3.506335e-13, 232,3.280540e-13,
+ 233,2.584948e-13, 234,4.776686e-13, 235,3.990983e-13, 236,5.109429e-13, 237,2.062138e-13, 238,2.061376e-13, 239,3.024893e-13, 240,2.235052e-13,
+ 241,2.846043e-13, 242,3.639268e-13, 243,3.817184e-13, 244,4.542389e-13, 245,3.259790e-13, 246,4.887445e-13, 247,2.594956e-13, 248,4.648337e-13,
+ 249,2.486711e-13, 250,1.883995e-13, 251,3.812301e-13, 252,2.375712e-13, 253,5.296728e-13, 254,1.682769e-13, 255,1.682769e-13, 256,5.296728e-13,
+ 257,1.682769e-13, 258,5.296728e-13, 259,5.296728e-13)
.param C7C=table(run, 1,2.156000e-11, 2,2.244000e-11, 3,2.169711e-11, 4,2.176951e-11, 5,2.158236e-11, 6,2.165052e-11, 7,2.225598e-11, 8,2.189464e-11,
+ 9,2.183851e-11, 10,2.218364e-11, 11,2.213750e-11, 12,2.223026e-11, 13,2.241841e-11, 14,2.170444e-11, 15,2.209120e-11, 16,2.235872e-11,
+ 17,2.206461e-11, 18,2.211108e-11, 19,2.158696e-11, 20,2.206278e-11, 21,2.185820e-11, 22,2.203240e-11, 23,2.208259e-11, 24,2.205627e-11,
+ 25,2.199696e-11, 26,2.239323e-11, 27,2.210432e-11, 28,2.228910e-11, 29,2.202353e-11, 30,2.199783e-11, 31,2.193436e-11, 32,2.179398e-11,
+ 33,2.160894e-11, 34,2.209444e-11, 35,2.217882e-11, 36,2.196206e-11, 37,2.157884e-11, 38,2.174168e-11, 39,2.156861e-11, 40,2.193087e-11,
+ 41,2.184615e-11, 42,2.165459e-11, 43,2.205499e-11, 44,2.208180e-11, 45,2.192753e-11, 46,2.204305e-11, 47,2.217390e-11, 48,2.159312e-11,
+ 49,2.230875e-11, 50,2.176041e-11, 51,2.164852e-11, 52,2.206522e-11, 53,2.219994e-11, 54,2.206634e-11, 55,2.236493e-11, 56,2.222457e-11,
+ 57,2.178367e-11, 58,2.229161e-11, 59,2.230002e-11, 60,2.213508e-11, 61,2.180759e-11, 62,2.205280e-11, 63,2.165600e-11, 64,2.225005e-11,
+ 65,2.202709e-11, 66,2.229798e-11, 67,2.216311e-11, 68,2.222107e-11, 69,2.187613e-11, 70,2.202547e-11, 71,2.166904e-11, 72,2.188882e-11,
+ 73,2.175754e-11, 74,2.176057e-11, 75,2.206420e-11, 76,2.163679e-11, 77,2.174524e-11, 78,2.176995e-11, 79,2.173198e-11, 80,2.200558e-11,
+ 81,2.219008e-11, 82,2.165562e-11, 83,2.192617e-11, 84,2.220304e-11, 85,2.229874e-11, 86,2.200045e-11, 87,2.222603e-11, 88,2.239860e-11,
+ 89,2.231861e-11, 90,2.228655e-11, 91,2.178046e-11, 92,2.209811e-11, 93,2.207188e-11, 94,2.181854e-11, 95,2.177987e-11, 96,2.203552e-11,
+ 97,2.216512e-11, 98,2.204511e-11, 99,2.220888e-11, 100,2.221564e-11, 101,2.238483e-11, 102,2.167359e-11, 103,2.196217e-11, 104,2.156134e-11,
+ 105,2.216249e-11, 106,2.197422e-11, 107,2.181170e-11, 108,2.197120e-11, 109,2.222311e-11, 110,2.166494e-11, 111,2.164691e-11, 112,2.161036e-11,
+ 113,2.200301e-11, 114,2.203971e-11, 115,2.197509e-11, 116,2.160505e-11, 117,2.217307e-11, 118,2.206030e-11, 119,2.170747e-11, 120,2.215642e-11,
+ 121,2.237361e-11, 122,2.161567e-11, 123,2.178047e-11, 124,2.234610e-11, 125,2.217798e-11, 126,2.200471e-11, 127,2.164088e-11, 128,2.226428e-11,
+ 129,2.175923e-11, 130,2.192186e-11, 131,2.211921e-11, 132,2.241819e-11, 133,2.183152e-11, 134,2.178819e-11, 135,2.225743e-11, 136,2.199781e-11,
+ 137,2.217396e-11, 138,2.204613e-11, 139,2.243393e-11, 140,2.203410e-11, 141,2.241388e-11, 142,2.202907e-11, 143,2.208287e-11, 144,2.216133e-11,
+ 145,2.226641e-11, 146,2.188724e-11, 147,2.240422e-11, 148,2.202145e-11, 149,2.182459e-11, 150,2.210222e-11, 151,2.201730e-11, 152,2.172401e-11,
+ 153,2.222942e-11, 154,2.242693e-11, 155,2.184047e-11, 156,2.226271e-11, 157,2.182077e-11, 158,2.239632e-11, 159,2.198503e-11, 160,2.171563e-11,
+ 161,2.223870e-11, 162,2.175570e-11, 163,2.242423e-11, 164,2.201843e-11, 165,2.216114e-11, 166,2.234916e-11, 167,2.224009e-11, 168,2.239955e-11,
+ 169,2.191496e-11, 170,2.219539e-11, 171,2.226989e-11, 172,2.234481e-11, 173,2.210683e-11, 174,2.215354e-11, 175,2.215303e-11, 176,2.216729e-11,
+ 177,2.188182e-11, 178,2.235357e-11, 179,2.178398e-11, 180,2.220661e-11, 181,2.205953e-11, 182,2.218643e-11, 183,2.160791e-11, 184,2.192514e-11,
+ 185,2.194591e-11, 186,2.197257e-11, 187,2.166753e-11, 188,2.187654e-11, 189,2.213098e-11, 190,2.197434e-11, 191,2.161551e-11, 192,2.219324e-11,
+ 193,2.228814e-11, 194,2.170252e-11, 195,2.217501e-11, 196,2.227970e-11, 197,2.160608e-11, 198,2.217667e-11, 199,2.182297e-11, 200,2.200749e-11,
+ 201,2.178363e-11, 202,2.163549e-11, 203,2.158581e-11, 204,2.212687e-11, 205,2.181911e-11, 206,2.195145e-11, 207,2.161043e-11, 208,2.182081e-11,
+ 209,2.194313e-11, 210,2.220925e-11, 211,2.204161e-11, 212,2.210331e-11, 213,2.178276e-11, 214,2.198783e-11, 215,2.169013e-11, 216,2.240222e-11,
+ 217,2.221592e-11, 218,2.215060e-11, 219,2.243690e-11, 220,2.217629e-11, 221,2.243694e-11, 222,2.217725e-11, 223,2.184438e-11, 224,2.200244e-11,
+ 225,2.195229e-11, 226,2.240278e-11, 227,2.211779e-11, 228,2.174306e-11, 229,2.156740e-11, 230,2.175111e-11, 231,2.167268e-11, 232,2.188757e-11,
+ 233,2.171602e-11, 234,2.199053e-11, 235,2.208750e-11, 236,2.231860e-11, 237,2.213427e-11, 238,2.185913e-11, 239,2.164490e-11, 240,2.166949e-11,
+ 241,2.202963e-11, 242,2.213022e-11, 243,2.180640e-11, 244,2.190766e-11, 245,2.200590e-11, 246,2.168184e-11, 247,2.176241e-11, 248,2.236673e-11,
+ 249,2.240968e-11, 250,2.235189e-11, 251,2.192014e-11, 252,2.214968e-11, 253,2.156000e-11, 254,2.156000e-11, 255,2.156000e-11, 256,2.244000e-11,
+ 257,2.156000e-11, 258,2.156000e-11, 259,2.244000e-11)
.param C7ESR=table(run, 1,2.000000e-01, 2,2.000000e-01, 3,2.704989e-01, 4,2.576986e-01, 5,1.728917e-01, 6,3.688375e-01, 7,2.500201e-01, 8,2.448635e-01,
+ 9,3.402546e-01, 10,2.138495e-01, 11,1.799870e-01, 12,2.956892e-01, 13,1.303731e-01, 14,1.619737e-01, 15,3.097156e-01, 16,2.971763e-01,
+ 17,2.949446e-01, 18,3.915305e-01, 19,3.791981e-01, 20,1.348679e-01, 21,2.811854e-01, 22,1.587682e-01, 23,2.990571e-01, 24,1.111545e-01,
+ 25,3.439244e-01, 26,1.112577e-01, 27,2.647503e-01, 28,1.173349e-01, 29,1.944373e-01, 30,1.593752e-01, 31,1.105798e-01, 32,2.228934e-01,
+ 33,3.977950e-01, 34,3.686896e-01, 35,1.885875e-01, 36,3.193553e-01, 37,2.187572e-01, 38,1.427872e-01, 39,1.066669e-01, 40,3.815497e-01,
+ 41,3.838713e-01, 42,3.327364e-01, 43,3.505193e-01, 44,3.379339e-01, 45,2.592738e-01, 46,1.714279e-01, 47,3.680911e-01, 48,3.830265e-01,
+ 49,3.425701e-01, 50,1.335878e-01, 51,1.205621e-01, 52,2.904559e-01, 53,3.929380e-01, 54,2.674292e-01, 55,2.058425e-01, 56,2.569928e-01,
+ 57,2.278144e-01, 58,2.559476e-01, 59,1.962684e-01, 60,1.547153e-01, 61,3.418371e-01, 62,3.761055e-01, 63,3.781890e-01, 64,2.474378e-01,
+ 65,3.507387e-01, 66,3.396229e-01, 67,3.976962e-01, 68,3.804389e-01, 69,2.610098e-01, 70,2.048159e-01, 71,3.035449e-01, 72,2.676388e-01,
+ 73,1.633215e-01, 74,3.385314e-01, 75,2.717032e-01, 76,2.390022e-01, 77,3.012584e-01, 78,2.487668e-01, 79,2.549190e-01, 80,3.167320e-01,
+ 81,3.640962e-01, 82,1.639253e-01, 83,1.700789e-01, 84,2.932937e-01, 85,3.115911e-01, 86,1.309351e-01, 87,2.980069e-01, 88,1.306240e-01,
+ 89,3.454799e-01, 90,3.488149e-01, 91,1.306835e-01, 92,3.962559e-01, 93,3.043165e-01, 94,2.450939e-01, 95,1.356799e-01, 96,2.785332e-01,
+ 97,2.679691e-01, 98,2.924383e-01, 99,2.592747e-01, 100,1.317288e-01, 101,1.279850e-01, 102,2.000118e-01, 103,2.035046e-01, 104,1.741503e-01,
+ 105,1.118261e-01, 106,1.182753e-01, 107,1.516244e-01, 108,3.598755e-01, 109,3.140793e-01, 110,2.653981e-01, 111,1.996883e-01, 112,3.453320e-01,
+ 113,2.870873e-01, 114,1.343620e-01, 115,2.166250e-01, 116,2.110467e-01, 117,1.535387e-01, 118,1.867012e-01, 119,3.327633e-01, 120,1.553853e-01,
+ 121,3.673443e-01, 122,1.603499e-01, 123,2.825557e-01, 124,1.508093e-01, 125,2.618051e-01, 126,3.799023e-01, 127,1.101684e-01, 128,2.794165e-01,
+ 129,1.803492e-01, 130,2.584480e-01, 131,2.250571e-01, 132,3.339166e-01, 133,3.318403e-01, 134,1.044268e-01, 135,1.604507e-01, 136,2.058589e-01,
+ 137,2.035727e-01, 138,3.126329e-01, 139,2.824266e-01, 140,1.124548e-01, 141,1.492859e-01, 142,1.216788e-01, 143,1.132353e-01, 144,2.200571e-01,
+ 145,2.146123e-01, 146,1.247164e-01, 147,1.525828e-01, 148,1.300567e-01, 149,1.480967e-01, 150,2.843093e-01, 151,3.049485e-01, 152,3.041469e-01,
+ 153,3.576002e-01, 154,2.023587e-01, 155,2.535825e-01, 156,1.242272e-01, 157,3.738753e-01, 158,1.778485e-01, 159,1.016332e-01, 160,1.376867e-01,
+ 161,2.569524e-01, 162,3.967276e-01, 163,3.206444e-01, 164,1.111567e-01, 165,2.720109e-01, 166,1.839696e-01, 167,3.155920e-01, 168,2.743163e-01,
+ 169,3.447156e-01, 170,1.667623e-01, 171,2.036959e-01, 172,2.114458e-01, 173,1.014264e-01, 174,2.701090e-01, 175,1.716726e-01, 176,3.665215e-01,
+ 177,3.767964e-01, 178,3.408865e-01, 179,3.979593e-01, 180,3.060787e-01, 181,3.908884e-01, 182,1.276832e-01, 183,1.340987e-01, 184,1.099427e-01,
+ 185,1.302391e-01, 186,2.922312e-01, 187,3.276542e-01, 188,1.652651e-01, 189,3.483840e-01, 190,2.270674e-01, 191,3.506499e-01, 192,2.369227e-01,
+ 193,2.740871e-01, 194,1.679859e-01, 195,3.387080e-01, 196,1.924062e-01, 197,3.700837e-01, 198,2.708288e-01, 199,3.302685e-01, 200,3.352553e-01,
+ 201,2.355333e-01, 202,3.479385e-01, 203,2.951849e-01, 204,2.468616e-01, 205,1.053676e-01, 206,2.530826e-01, 207,2.643944e-01, 208,2.412611e-01,
+ 209,2.427392e-01, 210,3.975195e-01, 211,2.881876e-01, 212,1.820606e-01, 213,1.376918e-01, 214,2.993763e-01, 215,3.977322e-01, 216,3.449960e-01,
+ 217,3.524074e-01, 218,2.630466e-01, 219,2.621565e-01, 220,3.618713e-01, 221,1.659703e-01, 222,3.949883e-01, 223,3.236505e-01, 224,3.913540e-01,
+ 225,3.535358e-01, 226,3.432285e-01, 227,1.596712e-01, 228,3.717984e-01, 229,3.963913e-01, 230,3.386489e-01, 231,2.146159e-01, 232,2.703362e-01,
+ 233,2.330303e-01, 234,2.868902e-01, 235,1.843494e-01, 236,2.454380e-01, 237,2.607519e-01, 238,1.991678e-01, 239,3.842437e-01, 240,1.242840e-01,
+ 241,1.570331e-01, 242,3.611126e-01, 243,2.769411e-01, 244,1.902322e-01, 245,1.852411e-01, 246,1.084957e-01, 247,1.289578e-01, 248,1.744440e-01,
+ 249,3.548304e-01, 250,1.356482e-01, 251,1.940745e-01, 252,2.106831e-01, 253,4.000000e-01, 254,1.000000e-01, 255,1.000000e-01, 256,1.000000e-01,
+ 257,1.000000e-01, 258,1.000000e-01, 259,1.000000e-01)
.param C7ESL=table(run, 1,1.000000e-09, 2,1.000000e-09, 3,7.561636e-10, 4,9.236703e-10, 5,1.167557e-09, 6,7.628914e-10, 7,8.322958e-10, 8,9.058361e-10,
+ 9,8.673054e-10, 10,6.049242e-10, 11,9.066870e-10, 12,7.081987e-10, 13,1.123495e-09, 14,9.539489e-10, 15,7.238251e-10, 16,7.654974e-10,
+ 17,1.181125e-09, 18,1.147797e-09, 19,8.597926e-10, 20,1.146707e-09, 21,8.560352e-10, 22,1.092262e-09, 23,1.036768e-09, 24,1.194885e-09,
+ 25,6.785394e-10, 26,9.548547e-10, 27,9.374992e-10, 28,1.114257e-09, 29,1.167087e-09, 30,1.178938e-09, 31,8.967264e-10, 32,6.526699e-10,
+ 33,7.994818e-10, 34,1.170722e-09, 35,6.588590e-10, 36,8.171777e-10, 37,1.012114e-09, 38,1.164287e-09, 39,9.229784e-10, 40,7.451182e-10,
+ 41,8.817621e-10, 42,7.105374e-10, 43,1.193670e-09, 44,1.103864e-09, 45,9.743024e-10, 46,1.185881e-09, 47,1.058083e-09, 48,7.190166e-10,
+ 49,1.071753e-09, 50,9.614999e-10, 51,9.107245e-10, 52,1.021171e-09, 53,9.282226e-10, 54,1.046795e-09, 55,1.113561e-09, 56,1.105636e-09,
+ 57,7.940093e-10, 58,6.828239e-10, 59,6.777469e-10, 60,6.761486e-10, 61,8.595079e-10, 62,1.196873e-09, 63,7.221170e-10, 64,7.753230e-10,
+ 65,7.560154e-10, 66,1.032098e-09, 67,1.040889e-09, 68,6.068140e-10, 69,1.163450e-09, 70,1.179547e-09, 71,8.483205e-10, 72,1.056683e-09,
+ 73,9.962752e-10, 74,8.559569e-10, 75,8.419319e-10, 76,6.817387e-10, 77,1.056823e-09, 78,8.114417e-10, 79,1.113615e-09, 80,6.567632e-10,
+ 81,1.138009e-09, 82,7.128515e-10, 83,1.091700e-09, 84,7.628961e-10, 85,8.305342e-10, 86,1.072993e-09, 87,7.404544e-10, 88,9.716148e-10,
+ 89,6.258716e-10, 90,7.262692e-10, 91,1.173065e-09, 92,6.895562e-10, 93,1.121371e-09, 94,9.037660e-10, 95,6.927217e-10, 96,8.679107e-10,
+ 97,1.002478e-09, 98,1.008218e-09, 99,6.134932e-10, 100,8.041708e-10, 101,6.325322e-10, 102,9.147479e-10, 103,8.353970e-10, 104,1.023409e-09,
+ 105,1.195081e-09, 106,9.636102e-10, 107,6.927018e-10, 108,9.514236e-10, 109,1.123274e-09, 110,1.176070e-09, 111,6.351011e-10, 112,6.373191e-10,
+ 113,6.459032e-10, 114,9.832729e-10, 115,6.942942e-10, 116,1.086350e-09, 117,7.917542e-10, 118,7.807770e-10, 119,9.088354e-10, 120,1.086307e-09,
+ 121,6.758754e-10, 122,6.989961e-10, 123,7.406253e-10, 124,8.737895e-10, 125,8.059737e-10, 126,1.031874e-09, 127,8.314146e-10, 128,1.073119e-09,
+ 129,1.062438e-09, 130,1.122203e-09, 131,1.183092e-09, 132,1.129851e-09, 133,1.030651e-09, 134,6.486671e-10, 135,6.911468e-10, 136,7.613273e-10,
+ 137,1.029703e-09, 138,1.161751e-09, 139,7.104240e-10, 140,7.761058e-10, 141,9.381369e-10, 142,1.025226e-09, 143,1.151888e-09, 144,9.272222e-10,
+ 145,7.498125e-10, 146,1.167940e-09, 147,7.669282e-10, 148,1.134394e-09, 149,6.834196e-10, 150,6.452378e-10, 151,8.220000e-10, 152,1.102666e-09,
+ 153,6.265464e-10, 154,1.051891e-09, 155,7.163851e-10, 156,8.239730e-10, 157,6.908398e-10, 158,6.874124e-10, 159,8.283991e-10, 160,9.659037e-10,
+ 161,6.578990e-10, 162,8.957057e-10, 163,6.841584e-10, 164,8.581973e-10, 165,6.426618e-10, 166,7.928945e-10, 167,8.159519e-10, 168,1.178789e-09,
+ 169,6.564869e-10, 170,6.789504e-10, 171,6.595372e-10, 172,1.189474e-09, 173,1.033260e-09, 174,9.003443e-10, 175,1.024713e-09, 176,1.054456e-09,
+ 177,7.235104e-10, 178,1.184910e-09, 179,9.269803e-10, 180,6.952760e-10, 181,6.535342e-10, 182,9.150719e-10, 183,1.032490e-09, 184,1.181375e-09,
+ 185,9.891843e-10, 186,7.425889e-10, 187,9.078252e-10, 188,1.046648e-09, 189,9.248193e-10, 190,9.193458e-10, 191,1.015809e-09, 192,6.094929e-10,
+ 193,8.368609e-10, 194,1.199339e-09, 195,1.063482e-09, 196,6.672820e-10, 197,7.215605e-10, 198,1.081879e-09, 199,8.475307e-10, 200,6.598248e-10,
+ 201,6.522575e-10, 202,9.796891e-10, 203,6.058374e-10, 204,8.105698e-10, 205,7.076890e-10, 206,7.461564e-10, 207,1.069000e-09, 208,7.010134e-10,
+ 209,8.885535e-10, 210,8.736969e-10, 211,8.466064e-10, 212,1.101429e-09, 213,1.154863e-09, 214,9.393220e-10, 215,7.596457e-10, 216,9.025796e-10,
+ 217,8.744213e-10, 218,8.253504e-10, 219,6.144788e-10, 220,6.007149e-10, 221,1.081309e-09, 222,6.463371e-10, 223,1.029712e-09, 224,1.154168e-09,
+ 225,9.712193e-10, 226,9.877707e-10, 227,6.396690e-10, 228,9.181513e-10, 229,7.623651e-10, 230,8.286483e-10, 231,6.053939e-10, 232,8.809873e-10,
+ 233,6.210536e-10, 234,7.012992e-10, 235,6.586764e-10, 236,1.190534e-09, 237,7.276814e-10, 238,8.314359e-10, 239,7.725662e-10, 240,8.790277e-10,
+ 241,1.143607e-09, 242,6.135262e-10, 243,8.162805e-10, 244,7.820610e-10, 245,6.931216e-10, 246,6.246458e-10, 247,7.849597e-10, 248,6.146220e-10,
+ 249,8.473458e-10, 250,6.798847e-10, 251,1.081829e-09, 252,1.016181e-09, 253,6.000000e-10, 254,6.000000e-10, 255,6.000000e-10, 256,1.200000e-09,
+ 257,6.000000e-10, 258,6.000000e-10, 259,1.200000e-09)
.param C7Lvia=table(run, 1,8.496433e-10, 2,8.496433e-10, 3,3.449263e-10, 4,3.559641e-10, 5,1.256570e-09, 6,3.755422e-10, 7,7.714432e-10, 8,5.057783e-10,
+ 9,8.934617e-10, 10,3.347401e-10, 11,3.799965e-10, 12,2.697356e-10, 13,1.235106e-09, 14,9.747146e-10, 15,1.047705e-09, 16,3.626169e-10,
+ 17,6.857209e-10, 18,7.943291e-10, 19,1.004082e-09, 20,9.303461e-10, 21,1.212738e-09, 22,3.203722e-10, 23,1.201293e-09, 24,9.653146e-10,
+ 25,8.973560e-10, 26,8.547881e-10, 27,9.338423e-10, 28,1.250558e-09, 29,5.199482e-10, 30,1.153831e-09, 31,8.522858e-10, 32,5.101013e-10,
+ 33,5.246626e-10, 34,9.467427e-10, 35,3.619469e-10, 36,8.499354e-10, 37,5.235420e-10, 38,1.121805e-09, 39,9.916534e-10, 40,9.832484e-10,
+ 41,9.628262e-10, 42,9.448315e-10, 43,5.586179e-10, 44,8.476857e-10, 45,5.363655e-10, 46,1.082472e-09, 47,8.602807e-10, 48,1.205944e-09,
+ 49,7.366571e-10, 50,4.113123e-10, 51,1.034363e-09, 52,9.019598e-10, 53,4.395662e-10, 54,3.639211e-10, 55,7.317516e-10, 56,1.209758e-09,
+ 57,3.165518e-10, 58,7.656000e-10, 59,1.231756e-09, 60,4.312327e-10, 61,1.065609e-09, 62,1.158192e-09, 63,5.015895e-10, 64,6.406960e-10,
+ 65,1.224734e-09, 66,7.294737e-10, 67,4.085489e-10, 68,3.234003e-10, 69,7.453102e-10, 70,9.672978e-10, 71,1.011026e-09, 72,1.298445e-09,
+ 73,2.977394e-10, 74,3.450742e-10, 75,4.534219e-10, 76,7.277511e-10, 77,3.736349e-10, 78,1.168083e-09, 79,7.663666e-10, 80,2.823914e-10,
+ 81,4.192824e-10, 82,1.027274e-09, 83,6.016627e-10, 84,5.916693e-10, 85,4.718966e-10, 86,1.176232e-09, 87,3.687272e-10, 88,4.237444e-10,
+ 89,1.081982e-09, 90,1.062314e-09, 91,5.500533e-10, 92,1.028793e-09, 93,5.859117e-10, 94,4.124885e-10, 95,8.925370e-10, 96,4.971716e-10,
+ 97,9.983583e-10, 98,5.560516e-10, 99,8.313564e-10, 100,5.118486e-10, 101,6.766415e-10, 102,1.063171e-09, 103,1.215694e-09, 104,8.274308e-10,
+ 105,3.307001e-10, 106,1.106981e-09, 107,9.012838e-10, 108,1.125981e-09, 109,4.297076e-10, 110,9.976964e-10, 111,8.362753e-10, 112,1.072633e-09,
+ 113,5.076484e-10, 114,4.078723e-10, 115,1.002604e-09, 116,1.009747e-09, 117,9.130192e-10, 118,1.193167e-09, 119,6.425142e-10, 120,3.921136e-10,
+ 121,5.984120e-10, 122,1.211338e-09, 123,8.700924e-10, 124,1.064606e-09, 125,7.988369e-10, 126,7.630482e-10, 127,4.956546e-10, 128,1.132055e-09,
+ 129,9.300498e-10, 130,7.461584e-10, 131,5.356344e-10, 132,6.981264e-10, 133,3.381685e-10, 134,1.255662e-09, 135,1.209974e-09, 136,7.525670e-10,
+ 137,1.264956e-09, 138,8.496259e-10, 139,9.192096e-10, 140,1.090646e-09, 141,8.223058e-10, 142,6.594075e-10, 143,3.237137e-10, 144,1.140719e-09,
+ 145,5.572561e-10, 146,9.458524e-10, 147,1.085366e-09, 148,4.822658e-10, 149,6.828953e-10, 150,4.815338e-10, 151,1.218608e-09, 152,3.660901e-10,
+ 153,1.045494e-09, 154,1.080411e-09, 155,4.127170e-10, 156,5.523904e-10, 157,1.113856e-09, 158,3.437031e-10, 159,3.311798e-10, 160,1.040744e-09,
+ 161,9.907964e-10, 162,6.370221e-10, 163,1.226672e-09, 164,9.910865e-10, 165,1.092819e-09, 166,8.511980e-10, 167,1.296860e-09, 168,1.278913e-09,
+ 169,1.184471e-09, 170,5.103109e-10, 171,4.506444e-10, 172,1.007686e-09, 173,7.137988e-10, 174,8.271496e-10, 175,4.611908e-10, 176,7.567506e-10,
+ 177,2.738744e-10, 178,8.287118e-10, 179,6.411521e-10, 180,1.072668e-09, 181,1.197897e-09, 182,1.011207e-09, 183,8.437027e-10, 184,8.125433e-10,
+ 185,7.412202e-10, 186,7.529201e-10, 187,4.489733e-10, 188,3.016069e-10, 189,1.210083e-09, 190,1.220451e-09, 191,5.989379e-10, 192,6.156423e-10,
+ 193,4.158235e-10, 194,3.631050e-10, 195,2.792016e-10, 196,8.019646e-10, 197,7.897817e-10, 198,1.070583e-09, 199,9.048117e-10, 200,2.891335e-10,
+ 201,6.025225e-10, 202,5.286850e-10, 203,1.042699e-09, 204,1.092388e-09, 205,5.010930e-10, 206,7.322849e-10, 207,4.936244e-10, 208,6.855220e-10,
+ 209,5.745973e-10, 210,3.446916e-10, 211,9.157109e-10, 212,2.964589e-10, 213,1.079436e-09, 214,3.939696e-10, 215,4.274197e-10, 216,8.161825e-10,
+ 217,1.024357e-09, 218,3.071994e-10, 219,6.962621e-10, 220,6.943380e-10, 221,7.001152e-10, 222,3.430224e-10, 223,8.815070e-10, 224,5.535146e-10,
+ 225,7.974704e-10, 226,4.378626e-10, 227,1.059240e-09, 228,4.519433e-10, 229,1.091679e-09, 230,5.638123e-10, 231,6.040082e-10, 232,8.320257e-10,
+ 233,7.362820e-10, 234,4.381601e-10, 235,5.858287e-10, 236,1.044714e-09, 237,2.910813e-10, 238,7.962690e-10, 239,1.202302e-09, 240,3.543886e-10,
+ 241,1.206011e-09, 242,1.248334e-09, 243,3.898333e-10, 244,1.190651e-09, 245,8.664841e-10, 246,1.100945e-09, 247,3.586098e-10, 248,5.265576e-10,
+ 249,9.179434e-10, 250,1.061893e-09, 251,5.455483e-10, 252,1.111012e-09, 253,2.693699e-10, 254,2.693699e-10, 255,2.693699e-10, 256,1.299287e-09,
+ 257,2.693699e-10, 258,2.693699e-10, 259,1.299287e-09)
.param C7Cpad=table(run, 1,3.489749e-13, 2,3.489749e-13, 3,3.215733e-13, 4,2.797112e-13, 5,2.465855e-13, 6,2.082029e-13, 7,5.185346e-13, 8,4.387965e-13,
+ 9,5.265883e-13, 10,3.535063e-13, 11,4.732488e-13, 12,4.459058e-13, 13,3.081649e-13, 14,2.356108e-13, 15,2.335656e-13, 16,4.685450e-13,
+ 17,3.871494e-13, 18,1.917023e-13, 19,3.753176e-13, 20,1.792601e-13, 21,4.995951e-13, 22,4.458948e-13, 23,3.610834e-13, 24,3.099157e-13,
+ 25,2.541913e-13, 26,2.310185e-13, 27,2.852103e-13, 28,4.710240e-13, 29,2.676470e-13, 30,3.512552e-13, 31,2.926131e-13, 32,4.302243e-13,
+ 33,2.862473e-13, 34,3.940846e-13, 35,5.129973e-13, 36,5.185004e-13, 37,4.694913e-13, 38,4.672554e-13, 39,2.469916e-13, 40,5.081223e-13,
+ 41,2.221313e-13, 42,2.309469e-13, 43,3.142288e-13, 44,2.285074e-13, 45,5.222939e-13, 46,3.191676e-13, 47,4.515695e-13, 48,5.048996e-13,
+ 49,4.200120e-13, 50,5.041217e-13, 51,2.197873e-13, 52,3.767555e-13, 53,2.564256e-13, 54,5.198626e-13, 55,5.223379e-13, 56,2.878811e-13,
+ 57,1.912251e-13, 58,3.051094e-13, 59,4.965050e-13, 60,3.930713e-13, 61,2.818036e-13, 62,4.545921e-13, 63,4.608011e-13, 64,4.842971e-13,
+ 65,2.314071e-13, 66,2.755075e-13, 67,2.761488e-13, 68,2.072357e-13, 69,2.994022e-13, 70,3.281276e-13, 71,5.275335e-13, 72,2.346713e-13,
+ 73,2.204912e-13, 74,4.011556e-13, 75,2.259975e-13, 76,3.206026e-13, 77,1.984226e-13, 78,1.839993e-13, 79,4.831152e-13, 80,4.879315e-13,
+ 81,2.760164e-13, 82,2.754228e-13, 83,3.631254e-13, 84,5.152256e-13, 85,4.842622e-13, 86,2.189600e-13, 87,3.347293e-13, 88,2.786277e-13,
+ 89,2.313438e-13, 90,4.086858e-13, 91,3.971895e-13, 92,4.207552e-13, 93,4.527244e-13, 94,4.190652e-13, 95,3.285184e-13, 96,1.772433e-13,
+ 97,3.444832e-13, 98,4.277208e-13, 99,3.153705e-13, 100,4.178393e-13, 101,2.431055e-13, 102,1.960621e-13, 103,2.255771e-13, 104,2.684708e-13,
+ 105,4.610323e-13, 106,3.299489e-13, 107,4.134718e-13, 108,3.407464e-13, 109,2.041999e-13, 110,1.999507e-13, 111,2.195896e-13, 112,3.416838e-13,
+ 113,3.237755e-13, 114,1.733858e-13, 115,4.940761e-13, 116,5.257519e-13, 117,3.605862e-13, 118,5.034428e-13, 119,3.708499e-13, 120,2.257711e-13,
+ 121,4.731063e-13, 122,3.784992e-13, 123,3.665998e-13, 124,2.385714e-13, 125,1.771094e-13, 126,4.433823e-13, 127,3.849231e-13, 128,2.471902e-13,
+ 129,2.831865e-13, 130,4.223426e-13, 131,3.453426e-13, 132,5.007544e-13, 133,2.062148e-13, 134,2.950835e-13, 135,2.258289e-13, 136,4.798167e-13,
+ 137,2.787924e-13, 138,3.161485e-13, 139,1.941564e-13, 140,4.280227e-13, 141,5.055255e-13, 142,3.280640e-13, 143,4.259601e-13, 144,3.209835e-13,
+ 145,4.215315e-13, 146,3.326160e-13, 147,2.028578e-13, 148,1.880951e-13, 149,4.705184e-13, 150,3.904464e-13, 151,3.568138e-13, 152,4.604303e-13,
+ 153,2.177968e-13, 154,1.844614e-13, 155,1.878886e-13, 156,4.136878e-13, 157,4.421192e-13, 158,3.144724e-13, 159,4.569937e-13, 160,3.919114e-13,
+ 161,3.722172e-13, 162,4.946313e-13, 163,3.074347e-13, 164,4.005859e-13, 165,2.230677e-13, 166,5.104719e-13, 167,4.804996e-13, 168,3.975215e-13,
+ 169,3.188462e-13, 170,1.876978e-13, 171,5.071261e-13, 172,4.732557e-13, 173,3.402999e-13, 174,3.103486e-13, 175,2.059961e-13, 176,4.573504e-13,
+ 177,3.439826e-13, 178,4.205257e-13, 179,5.271565e-13, 180,3.261470e-13, 181,1.795102e-13, 182,5.052355e-13, 183,1.832110e-13, 184,3.837341e-13,
+ 185,4.235447e-13, 186,2.724193e-13, 187,2.610162e-13, 188,4.799347e-13, 189,2.683352e-13, 190,2.658829e-13, 191,2.618570e-13, 192,4.242281e-13,
+ 193,2.227422e-13, 194,4.961858e-13, 195,4.873028e-13, 196,3.708819e-13, 197,2.239904e-13, 198,2.079209e-13, 199,1.951489e-13, 200,5.147124e-13,
+ 201,5.240550e-13, 202,5.011681e-13, 203,3.300958e-13, 204,2.642771e-13, 205,5.110824e-13, 206,3.579998e-13, 207,1.995809e-13, 208,4.001106e-13,
+ 209,1.755123e-13, 210,1.983737e-13, 211,4.826334e-13, 212,3.856941e-13, 213,3.902861e-13, 214,3.538234e-13, 215,2.400912e-13, 216,1.878555e-13,
+ 217,1.694733e-13, 218,2.547820e-13, 219,2.680359e-13, 220,3.605338e-13, 221,2.344466e-13, 222,4.584626e-13, 223,3.267747e-13, 224,3.563324e-13,
+ 225,3.720921e-13, 226,2.034172e-13, 227,2.464055e-13, 228,3.637334e-13, 229,4.678825e-13, 230,2.617594e-13, 231,3.614409e-13, 232,2.836810e-13,
+ 233,2.726607e-13, 234,1.948540e-13, 235,3.837300e-13, 236,5.133338e-13, 237,4.064794e-13, 238,4.105448e-13, 239,3.694280e-13, 240,2.466436e-13,
+ 241,3.331886e-13, 242,1.935637e-13, 243,2.601760e-13, 244,4.953506e-13, 245,1.773658e-13, 246,3.889922e-13, 247,1.834699e-13, 248,4.805026e-13,
+ 249,3.590751e-13, 250,2.161569e-13, 251,3.419149e-13, 252,3.180208e-13, 253,1.682769e-13, 254,1.682769e-13, 255,1.682769e-13, 256,5.296728e-13,
+ 257,1.682769e-13, 258,1.682769e-13, 259,5.296728e-13)
.param L2L=table(run, 1,6.664000e-08, 2,6.936000e-08, 3,6.930983e-08, 4,6.865279e-08, 5,6.687197e-08, 6,6.815304e-08, 7,6.845985e-08, 8,6.870211e-08,
+ 9,6.722288e-08, 10,6.913459e-08, 11,6.786116e-08, 12,6.898548e-08, 13,6.889429e-08, 14,6.908767e-08, 15,6.763357e-08, 16,6.928250e-08,
+ 17,6.749662e-08, 18,6.825902e-08, 19,6.786762e-08, 20,6.753605e-08, 21,6.684553e-08, 22,6.677508e-08, 23,6.793016e-08, 24,6.923679e-08,
+ 25,6.873187e-08, 26,6.815935e-08, 27,6.745509e-08, 28,6.721827e-08, 29,6.672088e-08, 30,6.730578e-08, 31,6.719286e-08, 32,6.898389e-08,
+ 33,6.846228e-08, 34,6.824258e-08, 35,6.674426e-08, 36,6.772311e-08, 37,6.704523e-08, 38,6.818762e-08, 39,6.882201e-08, 40,6.746859e-08,
+ 41,6.903758e-08, 42,6.804428e-08, 43,6.760803e-08, 44,6.747999e-08, 45,6.901198e-08, 46,6.691078e-08, 47,6.909374e-08, 48,6.847993e-08,
+ 49,6.799904e-08, 50,6.795213e-08, 51,6.798307e-08, 52,6.862457e-08, 53,6.886011e-08, 54,6.857619e-08, 55,6.751765e-08, 56,6.786463e-08,
+ 57,6.904019e-08, 58,6.894031e-08, 59,6.835049e-08, 60,6.789819e-08, 61,6.928055e-08, 62,6.802393e-08, 63,6.742246e-08, 64,6.750635e-08,
+ 65,6.781760e-08, 66,6.706840e-08, 67,6.797749e-08, 68,6.773013e-08, 69,6.777203e-08, 70,6.691023e-08, 71,6.678440e-08, 72,6.727095e-08,
+ 73,6.667518e-08, 74,6.810758e-08, 75,6.719002e-08, 76,6.719857e-08, 77,6.879341e-08, 78,6.707647e-08, 79,6.705159e-08, 80,6.667339e-08,
+ 81,6.893526e-08, 82,6.883502e-08, 83,6.934041e-08, 84,6.892177e-08, 85,6.734104e-08, 86,6.823566e-08, 87,6.789778e-08, 88,6.755864e-08,
+ 89,6.805964e-08, 90,6.722061e-08, 91,6.693459e-08, 92,6.796360e-08, 93,6.865941e-08, 94,6.740426e-08, 95,6.760625e-08, 96,6.893561e-08,
+ 97,6.769234e-08, 98,6.712514e-08, 99,6.738596e-08, 100,6.807425e-08, 101,6.743288e-08, 102,6.880084e-08, 103,6.882526e-08, 104,6.668937e-08,
+ 105,6.686421e-08, 106,6.729944e-08, 107,6.741255e-08, 108,6.889293e-08, 109,6.787839e-08, 110,6.868035e-08, 111,6.719526e-08, 112,6.889050e-08,
+ 113,6.869444e-08, 114,6.805082e-08, 115,6.891058e-08, 116,6.793857e-08, 117,6.786302e-08, 118,6.834598e-08, 119,6.780055e-08, 120,6.881222e-08,
+ 121,6.826068e-08, 122,6.696020e-08, 123,6.843159e-08, 124,6.774282e-08, 125,6.744829e-08, 126,6.845552e-08, 127,6.841857e-08, 128,6.673080e-08,
+ 129,6.717349e-08, 130,6.754406e-08, 131,6.911268e-08, 132,6.686157e-08, 133,6.843410e-08, 134,6.700761e-08, 135,6.829667e-08, 136,6.753216e-08,
+ 137,6.909035e-08, 138,6.836855e-08, 139,6.716317e-08, 140,6.798321e-08, 141,6.889692e-08, 142,6.727204e-08, 143,6.915740e-08, 144,6.690703e-08,
+ 145,6.841445e-08, 146,6.751565e-08, 147,6.670881e-08, 148,6.862945e-08, 149,6.859944e-08, 150,6.839988e-08, 151,6.786108e-08, 152,6.778533e-08,
+ 153,6.823057e-08, 154,6.732515e-08, 155,6.749807e-08, 156,6.819272e-08, 157,6.912884e-08, 158,6.749811e-08, 159,6.700653e-08, 160,6.744218e-08,
+ 161,6.849132e-08, 162,6.687235e-08, 163,6.898604e-08, 164,6.867955e-08, 165,6.894493e-08, 166,6.775769e-08, 167,6.692053e-08, 168,6.855401e-08,
+ 169,6.868087e-08, 170,6.701596e-08, 171,6.779656e-08, 172,6.779536e-08, 173,6.767448e-08, 174,6.825617e-08, 175,6.697309e-08, 176,6.678624e-08,
+ 177,6.700431e-08, 178,6.684674e-08, 179,6.788191e-08, 180,6.903754e-08, 181,6.798327e-08, 182,6.705303e-08, 183,6.673246e-08, 184,6.930463e-08,
+ 185,6.740375e-08, 186,6.769320e-08, 187,6.867230e-08, 188,6.716987e-08, 189,6.773875e-08, 190,6.804787e-08, 191,6.714966e-08, 192,6.785188e-08,
+ 193,6.886960e-08, 194,6.827472e-08, 195,6.764424e-08, 196,6.898128e-08, 197,6.798796e-08, 198,6.843568e-08, 199,6.743913e-08, 200,6.736530e-08,
+ 201,6.758650e-08, 202,6.813366e-08, 203,6.718837e-08, 204,6.932755e-08, 205,6.891259e-08, 206,6.804201e-08, 207,6.891706e-08, 208,6.666865e-08,
+ 209,6.853254e-08, 210,6.825848e-08, 211,6.883060e-08, 212,6.673185e-08, 213,6.725844e-08, 214,6.807648e-08, 215,6.758407e-08, 216,6.677669e-08,
+ 217,6.764309e-08, 218,6.847014e-08, 219,6.905424e-08, 220,6.817467e-08, 221,6.691324e-08, 222,6.767196e-08, 223,6.700775e-08, 224,6.927128e-08,
+ 225,6.727636e-08, 226,6.873637e-08, 227,6.771307e-08, 228,6.925695e-08, 229,6.749628e-08, 230,6.725952e-08, 231,6.703952e-08, 232,6.863047e-08,
+ 233,6.800378e-08, 234,6.896293e-08, 235,6.878843e-08, 236,6.861122e-08, 237,6.886897e-08, 238,6.805874e-08, 239,6.676702e-08, 240,6.775570e-08,
+ 241,6.817520e-08, 242,6.681566e-08, 243,6.784347e-08, 244,6.785111e-08, 245,6.806422e-08, 246,6.766724e-08, 247,6.909438e-08, 248,6.810997e-08,
+ 249,6.917024e-08, 250,6.747575e-08, 251,6.742140e-08, 252,6.722723e-08, 253,6.936000e-08, 254,6.664000e-08, 255,6.664000e-08, 256,6.664000e-08,
+ 257,6.664000e-08, 258,6.664000e-08, 259,6.936000e-08)
.param L2R=table(run, 1,6.280672e-01, 2,6.537026e-01, 3,6.004544e-01, 4,5.480411e-01, 5,5.475911e-01, 6,5.775646e-01, 7,5.768981e-01, 8,5.162822e-01,
+ 9,4.882430e-01, 10,5.118720e-01, 11,6.165338e-01, 12,5.740375e-01, 13,5.562707e-01, 14,6.248641e-01, 15,5.553273e-01, 16,5.639581e-01,
+ 17,4.936660e-01, 18,5.528535e-01, 19,5.944131e-01, 20,6.194192e-01, 21,5.619251e-01, 22,5.057492e-01, 23,5.647527e-01, 24,6.102441e-01,
+ 25,5.352490e-01, 26,5.001055e-01, 27,5.724971e-01, 28,5.646171e-01, 29,5.604016e-01, 30,4.984415e-01, 31,4.991570e-01, 32,5.093910e-01,
+ 33,5.405622e-01, 34,5.280639e-01, 35,5.780802e-01, 36,6.073392e-01, 37,4.964430e-01, 38,5.620546e-01, 39,5.201748e-01, 40,6.047316e-01,
+ 41,6.124130e-01, 42,5.377343e-01, 43,5.172916e-01, 44,5.535140e-01, 45,5.646923e-01, 46,4.877865e-01, 47,5.031544e-01, 48,6.102001e-01,
+ 49,4.957557e-01, 50,5.036050e-01, 51,5.701732e-01, 52,5.067924e-01, 53,6.345715e-01, 54,5.437676e-01, 55,4.930886e-01, 56,6.067742e-01,
+ 57,6.006174e-01, 58,5.785440e-01, 59,6.434888e-01, 60,4.949828e-01, 61,5.443805e-01, 62,5.301422e-01, 63,5.079596e-01, 64,5.556688e-01,
+ 65,5.004005e-01, 66,5.614936e-01, 67,6.010815e-01, 68,4.935677e-01, 69,4.934291e-01, 70,5.771271e-01, 71,5.586404e-01, 72,6.299436e-01,
+ 73,5.020534e-01, 74,6.139580e-01, 75,5.001921e-01, 76,4.893044e-01, 77,5.286307e-01, 78,5.358964e-01, 79,6.196171e-01, 80,5.480686e-01,
+ 81,5.564776e-01, 82,6.282771e-01, 83,6.397052e-01, 84,5.465822e-01, 85,5.670805e-01, 86,5.290458e-01, 87,4.923898e-01, 88,5.832937e-01,
+ 89,5.779746e-01, 90,5.898819e-01, 91,5.220846e-01, 92,6.082479e-01, 93,5.567086e-01, 94,5.472212e-01, 95,5.944830e-01, 96,5.091304e-01,
+ 97,4.982374e-01, 98,6.019646e-01, 99,5.463964e-01, 100,5.412866e-01, 101,5.960622e-01, 102,5.322680e-01, 103,5.429570e-01, 104,5.688627e-01,
+ 105,4.911798e-01, 106,5.868967e-01, 107,4.934963e-01, 108,6.308700e-01, 109,5.705160e-01, 110,6.154657e-01, 111,5.680420e-01, 112,5.175204e-01,
+ 113,5.992109e-01, 114,6.117608e-01, 115,5.612216e-01, 116,5.445719e-01, 117,5.913438e-01, 118,5.704805e-01, 119,6.094438e-01, 120,5.342961e-01,
+ 121,5.408184e-01, 122,5.834491e-01, 123,6.103785e-01, 124,6.021085e-01, 125,4.966934e-01, 126,5.226173e-01, 127,5.079869e-01, 128,5.205622e-01,
+ 129,5.484585e-01, 130,6.204220e-01, 131,6.130006e-01, 132,6.138007e-01, 133,5.329740e-01, 134,6.188970e-01, 135,5.486907e-01, 136,5.666753e-01,
+ 137,5.524960e-01, 138,5.063641e-01, 139,6.219052e-01, 140,5.802272e-01, 141,6.098662e-01, 142,5.628018e-01, 143,5.107714e-01, 144,5.521412e-01,
+ 145,5.508193e-01, 146,4.992486e-01, 147,6.011287e-01, 148,5.375143e-01, 149,5.530495e-01, 150,5.085894e-01, 151,5.688558e-01, 152,5.138356e-01,
+ 153,5.739438e-01, 154,5.811676e-01, 155,6.066399e-01, 156,5.648797e-01, 157,6.027098e-01, 158,6.301147e-01, 159,5.759320e-01, 160,5.016859e-01,
+ 161,5.073851e-01, 162,4.973298e-01, 163,6.434019e-01, 164,6.360576e-01, 165,6.315574e-01, 166,5.771945e-01, 167,5.922049e-01, 168,6.231594e-01,
+ 169,5.722483e-01, 170,5.280684e-01, 171,5.733065e-01, 172,5.466235e-01, 173,5.857471e-01, 174,5.366320e-01, 175,5.600127e-01, 176,4.940044e-01,
+ 177,4.955153e-01, 178,5.955063e-01, 179,6.288757e-01, 180,5.512614e-01, 181,6.401863e-01, 182,6.315886e-01, 183,5.796183e-01, 184,6.204552e-01,
+ 185,6.098717e-01, 186,5.912293e-01, 187,5.012034e-01, 188,6.073339e-01, 189,5.782633e-01, 190,6.173050e-01, 191,5.289794e-01, 192,5.111543e-01,
+ 193,5.166243e-01, 194,5.505083e-01, 195,5.055475e-01, 196,5.809051e-01, 197,5.867539e-01, 198,6.160618e-01, 199,5.218764e-01, 200,5.718646e-01,
+ 201,5.283157e-01, 202,6.105637e-01, 203,5.561850e-01, 204,5.730362e-01, 205,6.200969e-01, 206,6.215067e-01, 207,5.389863e-01, 208,5.842080e-01,
+ 209,5.337525e-01, 210,5.305723e-01, 211,6.136523e-01, 212,5.283273e-01, 213,5.528834e-01, 214,5.271413e-01, 215,5.049228e-01, 216,6.047915e-01,
+ 217,5.386658e-01, 218,5.167573e-01, 219,5.695315e-01, 220,6.228573e-01, 221,5.792224e-01, 222,5.187223e-01, 223,5.806602e-01, 224,5.359436e-01,
+ 225,5.721665e-01, 226,5.326170e-01, 227,6.093241e-01, 228,5.293779e-01, 229,6.294375e-01, 230,4.953942e-01, 231,5.346114e-01, 232,5.721318e-01,
+ 233,5.938057e-01, 234,5.610808e-01, 235,5.585368e-01, 236,5.523501e-01, 237,6.101291e-01, 238,6.374057e-01, 239,5.308362e-01, 240,5.964208e-01,
+ 241,5.382153e-01, 242,5.141651e-01, 243,5.898635e-01, 244,5.106638e-01, 245,5.363838e-01, 246,5.504750e-01, 247,5.113408e-01, 248,5.009520e-01,
+ 249,5.040581e-01, 250,5.835382e-01, 251,5.060966e-01, 252,5.815363e-01, 253,6.537026e-01, 254,4.831286e-01, 255,4.831286e-01, 256,4.831286e-01,
+ 257,6.280672e-01, 258,6.280672e-01, 259,6.537026e-01)
.param L2C=table(run, 1,2.189362e-13, 2,2.123113e-13, 3,1.721255e-13, 4,1.448656e-13, 5,1.943649e-13, 6,1.792149e-13, 7,2.015644e-13, 8,1.750507e-13,
+ 9,2.114649e-13, 10,2.246047e-13, 11,1.653912e-13, 12,1.475608e-13, 13,1.286774e-13, 14,1.924410e-13, 15,1.620022e-13, 16,1.697350e-13,
+ 17,1.359676e-13, 18,1.770907e-13, 19,1.303375e-13, 20,1.339443e-13, 21,2.191454e-13, 22,1.965495e-13, 23,2.107364e-13, 24,1.874940e-13,
+ 25,1.984272e-13, 26,2.167017e-13, 27,1.370595e-13, 28,2.081426e-13, 29,1.401068e-13, 30,2.295245e-13, 31,1.906517e-13, 32,2.081777e-13,
+ 33,1.944616e-13, 34,1.547619e-13, 35,2.205943e-13, 36,1.843181e-13, 37,1.915491e-13, 38,1.708776e-13, 39,1.519865e-13, 40,1.645548e-13,
+ 41,1.464501e-13, 42,1.759700e-13, 43,1.851003e-13, 44,1.752658e-13, 45,1.597751e-13, 46,2.213228e-13, 47,1.885951e-13, 48,1.697732e-13,
+ 49,1.994228e-13, 50,1.457121e-13, 51,2.177382e-13, 52,1.257965e-13, 53,1.719510e-13, 54,1.451003e-13, 55,1.605065e-13, 56,1.850837e-13,
+ 57,1.399606e-13, 58,1.806250e-13, 59,1.420447e-13, 60,1.919915e-13, 61,1.701865e-13, 62,1.453180e-13, 63,1.727649e-13, 64,1.730372e-13,
+ 65,1.269390e-13, 66,1.839692e-13, 67,1.581055e-13, 68,1.542103e-13, 69,1.879615e-13, 70,1.991622e-13, 71,1.928336e-13, 72,2.225145e-13,
+ 73,1.805804e-13, 74,1.977891e-13, 75,1.781891e-13, 76,1.583389e-13, 77,1.173302e-13, 78,1.655399e-13, 79,1.821713e-13, 80,1.700885e-13,
+ 81,2.270208e-13, 82,1.475415e-13, 83,1.859012e-13, 84,2.069863e-13, 85,2.369507e-13, 86,1.509321e-13, 87,1.591153e-13, 88,1.472944e-13,
+ 89,1.586473e-13, 90,1.645541e-13, 91,1.861853e-13, 92,1.953463e-13, 93,2.078607e-13, 94,1.567360e-13, 95,1.941600e-13, 96,1.766350e-13,
+ 97,1.997347e-13, 98,2.043281e-13, 99,2.210481e-13, 100,1.824302e-13, 101,1.675088e-13, 102,2.122765e-13, 103,1.439311e-13, 104,1.928289e-13,
+ 105,1.732217e-13, 106,1.634442e-13, 107,1.788254e-13, 108,1.752355e-13, 109,2.061098e-13, 110,1.755595e-13, 111,1.438534e-13, 112,1.548116e-13,
+ 113,1.588156e-13, 114,1.560737e-13, 115,1.826687e-13, 116,1.905246e-13, 117,1.785483e-13, 118,1.561857e-13, 119,1.949505e-13, 120,1.759496e-13,
+ 121,1.929258e-13, 122,1.954607e-13, 123,1.970532e-13, 124,1.798427e-13, 125,1.995529e-13, 126,1.474088e-13, 127,1.956929e-13, 128,1.950233e-13,
+ 129,1.547584e-13, 130,1.795167e-13, 131,1.679099e-13, 132,1.582185e-13, 133,1.849038e-13, 134,2.108028e-13, 135,1.621679e-13, 136,1.357917e-13,
+ 137,1.696773e-13, 138,2.249542e-13, 139,1.593525e-13, 140,1.895695e-13, 141,1.995907e-13, 142,1.487374e-13, 143,1.603075e-13, 144,1.899525e-13,
+ 145,1.664902e-13, 146,2.076617e-13, 147,2.295318e-13, 148,1.568695e-13, 149,1.316372e-13, 150,1.735462e-13, 151,1.912631e-13, 152,1.675674e-13,
+ 153,1.762227e-13, 154,1.773280e-13, 155,1.651914e-13, 156,2.134198e-13, 157,1.985455e-13, 158,1.761105e-13, 159,2.170637e-13, 160,1.771480e-13,
+ 161,1.403539e-13, 162,1.675975e-13, 163,1.589993e-13, 164,1.604952e-13, 165,1.447390e-13, 166,1.265901e-13, 167,2.305833e-13, 168,1.316349e-13,
+ 169,2.234305e-13, 170,1.396429e-13, 171,1.756426e-13, 172,1.574972e-13, 173,1.875487e-13, 174,1.676777e-13, 175,2.062516e-13, 176,2.232811e-13,
+ 177,1.786713e-13, 178,1.927445e-13, 179,2.178409e-13, 180,1.756020e-13, 181,1.540503e-13, 182,2.235142e-13, 183,1.995266e-13, 184,1.919603e-13,
+ 185,1.644436e-13, 186,1.607420e-13, 187,2.081506e-13, 188,1.265595e-13, 189,1.924414e-13, 190,1.418936e-13, 191,1.822753e-13, 192,2.213432e-13,
+ 193,1.473196e-13, 194,2.099444e-13, 195,1.548240e-13, 196,1.834578e-13, 197,1.487610e-13, 198,1.741324e-13, 199,1.817755e-13, 200,1.691978e-13,
+ 201,1.923872e-13, 202,2.091714e-13, 203,2.037461e-13, 204,1.788444e-13, 205,2.004071e-13, 206,1.867924e-13, 207,1.611791e-13, 208,1.556976e-13,
+ 209,1.385246e-13, 210,1.950056e-13, 211,1.502691e-13, 212,1.819949e-13, 213,1.656669e-13, 214,1.553981e-13, 215,2.035427e-13, 216,2.063970e-13,
+ 217,1.811448e-13, 218,2.048828e-13, 219,1.844805e-13, 220,1.604028e-13, 221,1.868159e-13, 222,1.513339e-13, 223,1.477169e-13, 224,1.506473e-13,
+ 225,1.475356e-13, 226,1.362374e-13, 227,1.779652e-13, 228,2.183678e-13, 229,2.139445e-13, 230,1.773695e-13, 231,2.095854e-13, 232,1.887413e-13,
+ 233,1.950044e-13, 234,1.500806e-13, 235,1.645439e-13, 236,2.108307e-13, 237,1.504689e-13, 238,1.941891e-13, 239,1.502991e-13, 240,1.612057e-13,
+ 241,1.969184e-13, 242,2.353216e-13, 243,1.889706e-13, 244,1.271485e-13, 245,2.224887e-13, 246,2.246026e-13, 247,1.800808e-13, 248,1.816986e-13,
+ 249,1.746744e-13, 250,1.845005e-13, 251,1.640210e-13, 252,1.606667e-13, 253,2.423113e-13, 254,1.199623e-13, 255,1.199623e-13, 256,2.489362e-13,
+ 257,1.199623e-13, 258,1.199623e-13, 259,2.423113e-13)
.param L2Ltr=table(run, 1,1.000000e-09, 2,1.000000e-09, 3,1.842207e-09, 4,9.304589e-10, 5,1.152872e-09, 6,1.364113e-09, 7,9.807315e-10, 8,7.592731e-10,
+ 9,1.068390e-09, 10,1.762211e-09, 11,1.198178e-09, 12,1.697304e-09, 13,1.527040e-09, 14,1.851604e-09, 15,5.607341e-10, 16,6.713326e-10,
+ 17,5.852185e-10, 18,9.378363e-10, 19,1.801600e-09, 20,9.157420e-10, 21,1.053992e-09, 22,9.175871e-10, 23,1.928085e-09, 24,1.499225e-09,
+ 25,1.692344e-09, 26,1.675210e-09, 27,1.838432e-09, 28,1.725503e-09, 29,7.758835e-10, 30,1.635225e-09, 31,8.217288e-10, 32,6.886234e-10,
+ 33,1.305062e-09, 34,1.491990e-09, 35,1.313464e-09, 36,1.308251e-09, 37,6.955450e-10, 38,1.252407e-09, 39,6.016603e-10, 40,1.673724e-09,
+ 41,9.723052e-10, 42,8.953574e-10, 43,1.132482e-09, 44,1.617688e-09, 45,5.698600e-10, 46,1.758985e-09, 47,9.404275e-10, 48,8.738168e-10,
+ 49,1.712565e-09, 50,1.446706e-09, 51,8.500507e-10, 52,1.436997e-09, 53,1.775756e-09, 54,1.417149e-09, 55,1.057866e-09, 56,1.144371e-09,
+ 57,1.857883e-09, 58,1.010683e-09, 59,1.083000e-09, 60,1.511547e-09, 61,1.160499e-09, 62,7.870788e-10, 63,1.384376e-09, 64,1.193396e-09,
+ 65,1.495731e-09, 66,9.413874e-10, 67,1.859631e-09, 68,1.418868e-09, 69,7.743303e-10, 70,1.820506e-09, 71,1.527719e-09, 72,1.432995e-09,
+ 73,5.395283e-10, 74,1.167121e-09, 75,9.981956e-10, 76,1.936505e-09, 77,1.920188e-09, 78,1.909852e-09, 79,1.188097e-09, 80,1.431132e-09,
+ 81,1.425524e-09, 82,9.570776e-10, 83,1.120127e-09, 84,5.611474e-10, 85,1.682012e-09, 86,1.870243e-09, 87,1.988802e-09, 88,1.797189e-09,
+ 89,1.925273e-09, 90,9.914037e-10, 91,8.155869e-10, 92,1.360343e-09, 93,1.860173e-09, 94,1.416663e-09, 95,1.062487e-09, 96,1.383358e-09,
+ 97,1.053634e-09, 98,1.311269e-09, 99,1.480441e-09, 100,7.014776e-10, 101,1.348217e-09, 102,1.372362e-09, 103,1.219175e-09, 104,1.242497e-09,
+ 105,1.848361e-09, 106,9.381911e-10, 107,1.492136e-09, 108,9.647228e-10, 109,1.970540e-09, 110,1.976205e-09, 111,7.695468e-10, 112,9.027362e-10,
+ 113,1.007093e-09, 114,1.485028e-09, 115,1.833006e-09, 116,7.144777e-10, 117,9.024731e-10, 118,6.779532e-10, 119,1.512387e-09, 120,9.635908e-10,
+ 121,1.005454e-09, 122,1.498503e-09, 123,1.152652e-09, 124,9.219552e-10, 125,6.698581e-10, 126,5.712547e-10, 127,1.907835e-09, 128,1.369537e-09,
+ 129,1.869237e-09, 130,1.981861e-09, 131,1.941542e-09, 132,7.932668e-10, 133,1.650126e-09, 134,1.128163e-09, 135,1.755125e-09, 136,1.030708e-09,
+ 137,1.409563e-09, 138,5.447810e-10, 139,1.915188e-09, 140,1.859169e-09, 141,1.727324e-09, 142,9.703036e-10, 143,1.437522e-09, 144,1.358954e-09,
+ 145,7.838521e-10, 146,1.574703e-09, 147,1.326016e-09, 148,5.958768e-10, 149,1.078422e-09, 150,9.962750e-10, 151,1.176446e-09, 152,1.926751e-09,
+ 153,1.168393e-09, 154,1.898894e-09, 155,8.422852e-10, 156,9.144756e-10, 157,5.216664e-10, 158,8.935750e-10, 159,6.428472e-10, 160,1.535112e-09,
+ 161,1.878709e-09, 162,8.031907e-10, 163,8.659197e-10, 164,1.716039e-09, 165,1.453581e-09, 166,1.214950e-09, 167,6.305940e-10, 168,8.032202e-10,
+ 169,1.710300e-09, 170,8.026823e-10, 171,9.689541e-10, 172,8.128754e-10, 173,1.314553e-09, 174,9.114298e-10, 175,1.040356e-09, 176,7.444313e-10,
+ 177,1.019578e-09, 178,5.516842e-10, 179,1.849494e-09, 180,8.578741e-10, 181,1.985872e-09, 182,1.607921e-09, 183,5.147882e-10, 184,1.639495e-09,
+ 185,7.309633e-10, 186,1.758478e-09, 187,8.419788e-10, 188,1.014081e-09, 189,9.442433e-10, 190,1.031535e-09, 191,1.019312e-09, 192,1.612248e-09,
+ 193,1.293441e-09, 194,1.606029e-09, 195,1.495773e-09, 196,5.155686e-10, 197,1.322938e-09, 198,1.103086e-09, 199,1.959621e-09, 200,1.037036e-09,
+ 201,6.113047e-10, 202,5.989051e-10, 203,5.310160e-10, 204,1.997207e-09, 205,1.449878e-09, 206,6.435256e-10, 207,7.427360e-10, 208,1.507595e-09,
+ 209,5.576113e-10, 210,1.487311e-09, 211,7.424997e-10, 212,6.439530e-10, 213,1.730370e-09, 214,5.037291e-10, 215,7.604453e-10, 216,1.169327e-09,
+ 217,1.580170e-09, 218,8.160605e-10, 219,1.746800e-09, 220,1.070027e-09, 221,1.265439e-09, 222,1.690132e-09, 223,1.790215e-09, 224,9.083981e-10,
+ 225,1.270810e-09, 226,1.066169e-09, 227,9.703020e-10, 228,5.360518e-10, 229,1.680304e-09, 230,1.448958e-09, 231,8.998830e-10, 232,1.197036e-09,
+ 233,6.747059e-10, 234,6.152714e-10, 235,7.181837e-10, 236,1.307548e-09, 237,9.245091e-10, 238,5.447643e-10, 239,1.049838e-09, 240,7.001964e-10,
+ 241,1.127091e-09, 242,6.375401e-10, 243,7.986997e-10, 244,7.761603e-10, 245,1.703515e-09, 246,6.266202e-10, 247,1.042898e-09, 248,1.721201e-09,
+ 249,1.554687e-09, 250,1.124893e-09, 251,7.021907e-10, 252,1.435662e-09, 253,2.000000e-09, 254,5.000000e-10, 255,5.000000e-10, 256,2.000000e-09,
+ 257,5.000000e-10, 258,5.000000e-10, 259,2.000000e-09)
.param L4L=table(run, 1,8.036000e-08, 2,8.364000e-08, 3,8.082986e-08, 4,8.157834e-08, 5,8.237567e-08, 6,8.346613e-08, 7,8.170616e-08, 8,8.171887e-08,
+ 9,8.290068e-08, 10,8.142509e-08, 11,8.184360e-08, 12,8.330659e-08, 13,8.136620e-08, 14,8.179716e-08, 15,8.170743e-08, 16,8.212573e-08,
+ 17,8.238995e-08, 18,8.361254e-08, 19,8.287706e-08, 20,8.295870e-08, 21,8.137982e-08, 22,8.198125e-08, 23,8.291346e-08, 24,8.146660e-08,
+ 25,8.054437e-08, 26,8.187937e-08, 27,8.206629e-08, 28,8.357653e-08, 29,8.158544e-08, 30,8.151575e-08, 31,8.181949e-08, 32,8.185999e-08,
+ 33,8.157257e-08, 34,8.354085e-08, 35,8.361979e-08, 36,8.336814e-08, 37,8.165379e-08, 38,8.043483e-08, 39,8.056962e-08, 40,8.052452e-08,
+ 41,8.346143e-08, 42,8.185818e-08, 43,8.150806e-08, 44,8.334963e-08, 45,8.088023e-08, 46,8.112230e-08, 47,8.295402e-08, 48,8.275543e-08,
+ 49,8.274825e-08, 50,8.273381e-08, 51,8.292144e-08, 52,8.317702e-08, 53,8.124943e-08, 54,8.161379e-08, 55,8.098117e-08, 56,8.062831e-08,
+ 57,8.323539e-08, 58,8.271070e-08, 59,8.242104e-08, 60,8.278854e-08, 61,8.171005e-08, 62,8.286789e-08, 63,8.143202e-08, 64,8.262097e-08,
+ 65,8.119618e-08, 66,8.260946e-08, 67,8.182351e-08, 68,8.153362e-08, 69,8.081212e-08, 70,8.146101e-08, 71,8.221362e-08, 72,8.144496e-08,
+ 73,8.087051e-08, 74,8.185494e-08, 75,8.122213e-08, 76,8.126049e-08, 77,8.237103e-08, 78,8.242720e-08, 79,8.173899e-08, 80,8.072133e-08,
+ 81,8.132421e-08, 82,8.120164e-08, 83,8.288845e-08, 84,8.334544e-08, 85,8.065714e-08, 86,8.337293e-08, 87,8.105973e-08, 88,8.052021e-08,
+ 89,8.146639e-08, 90,8.140504e-08, 91,8.109138e-08, 92,8.178747e-08, 93,8.122547e-08, 94,8.149563e-08, 95,8.290378e-08, 96,8.195999e-08,
+ 97,8.064647e-08, 98,8.048110e-08, 99,8.151854e-08, 100,8.247956e-08, 101,8.198559e-08, 102,8.159865e-08, 103,8.133634e-08, 104,8.207202e-08,
+ 105,8.162572e-08, 106,8.040616e-08, 107,8.160139e-08, 108,8.165138e-08, 109,8.238955e-08, 110,8.172109e-08, 111,8.309311e-08, 112,8.356134e-08,
+ 113,8.076155e-08, 114,8.314805e-08, 115,8.146277e-08, 116,8.267670e-08, 117,8.061972e-08, 118,8.190687e-08, 119,8.238295e-08, 120,8.174568e-08,
+ 121,8.256352e-08, 122,8.328490e-08, 123,8.187304e-08, 124,8.103932e-08, 125,8.106845e-08, 126,8.110072e-08, 127,8.313033e-08, 128,8.320348e-08,
+ 129,8.307808e-08, 130,8.276332e-08, 131,8.267407e-08, 132,8.195275e-08, 133,8.121014e-08, 134,8.281530e-08, 135,8.133887e-08, 136,8.330313e-08,
+ 137,8.244849e-08, 138,8.300040e-08, 139,8.112664e-08, 140,8.040059e-08, 141,8.360526e-08, 142,8.231526e-08, 143,8.307880e-08, 144,8.337600e-08,
+ 145,8.160238e-08, 146,8.110405e-08, 147,8.123103e-08, 148,8.346429e-08, 149,8.238049e-08, 150,8.048799e-08, 151,8.310793e-08, 152,8.293418e-08,
+ 153,8.118856e-08, 154,8.088902e-08, 155,8.360978e-08, 156,8.070173e-08, 157,8.202257e-08, 158,8.100617e-08, 159,8.148334e-08, 160,8.163684e-08,
+ 161,8.189378e-08, 162,8.154585e-08, 163,8.060338e-08, 164,8.169557e-08, 165,8.263535e-08, 166,8.236992e-08, 167,8.186105e-08, 168,8.247159e-08,
+ 169,8.289554e-08, 170,8.313749e-08, 171,8.208677e-08, 172,8.313789e-08, 173,8.088746e-08, 174,8.273829e-08, 175,8.149000e-08, 176,8.248518e-08,
+ 177,8.133433e-08, 178,8.356568e-08, 179,8.195640e-08, 180,8.037874e-08, 181,8.107266e-08, 182,8.216867e-08, 183,8.340736e-08, 184,8.132281e-08,
+ 185,8.312624e-08, 186,8.299106e-08, 187,8.194765e-08, 188,8.341113e-08, 189,8.255810e-08, 190,8.074142e-08, 191,8.093770e-08, 192,8.206000e-08,
+ 193,8.261445e-08, 194,8.326736e-08, 195,8.292074e-08, 196,8.070603e-08, 197,8.154450e-08, 198,8.045029e-08, 199,8.078433e-08, 200,8.308123e-08,
+ 201,8.298544e-08, 202,8.175823e-08, 203,8.129354e-08, 204,8.203214e-08, 205,8.092035e-08, 206,8.351571e-08, 207,8.202747e-08, 208,8.142868e-08,
+ 209,8.213161e-08, 210,8.201907e-08, 211,8.347488e-08, 212,8.036875e-08, 213,8.129380e-08, 214,8.296698e-08, 215,8.080955e-08, 216,8.362566e-08,
+ 217,8.149153e-08, 218,8.235767e-08, 219,8.184863e-08, 220,8.262448e-08, 221,8.280668e-08, 222,8.171848e-08, 223,8.058986e-08, 224,8.138586e-08,
+ 225,8.053291e-08, 226,8.143243e-08, 227,8.152564e-08, 228,8.141213e-08, 229,8.145926e-08, 230,8.178836e-08, 231,8.156388e-08, 232,8.197786e-08,
+ 233,8.049483e-08, 234,8.068575e-08, 235,8.189442e-08, 236,8.316146e-08, 237,8.069626e-08, 238,8.140416e-08, 239,8.037840e-08, 240,8.274652e-08,
+ 241,8.130988e-08, 242,8.142467e-08, 243,8.289507e-08, 244,8.147558e-08, 245,8.042224e-08, 246,8.200975e-08, 247,8.238882e-08, 248,8.344511e-08,
+ 249,8.244355e-08, 250,8.274257e-08, 251,8.344810e-08, 252,8.288385e-08, 253,8.364000e-08, 254,8.036000e-08, 255,8.364000e-08, 256,8.036000e-08,
+ 257,8.036000e-08, 258,8.364000e-08, 259,8.364000e-08)
.param L4R=table(run, 1,7.573752e-01, 2,7.882884e-01, 3,5.871725e-01, 4,7.508491e-01, 5,6.166950e-01, 6,6.998474e-01, 7,6.648576e-01, 8,7.194363e-01,
+ 9,7.432014e-01, 10,6.350403e-01, 11,6.709551e-01, 12,6.533207e-01, 13,5.910166e-01, 14,6.576862e-01, 15,6.116995e-01, 16,7.004819e-01,
+ 17,7.054175e-01, 18,6.660678e-01, 19,6.355360e-01, 20,7.442767e-01, 21,7.045212e-01, 22,6.962127e-01, 23,7.680338e-01, 24,6.424375e-01,
+ 25,5.884451e-01, 26,7.675887e-01, 27,6.837210e-01, 28,6.907997e-01, 29,6.759115e-01, 30,7.230724e-01, 31,6.433221e-01, 32,7.580107e-01,
+ 33,6.416093e-01, 34,7.080479e-01, 35,6.662353e-01, 36,6.198927e-01, 37,7.379254e-01, 38,7.501517e-01, 39,6.475373e-01, 40,6.358623e-01,
+ 41,7.364191e-01, 42,7.580825e-01, 43,6.206701e-01, 44,7.372585e-01, 45,7.401560e-01, 46,7.443495e-01, 47,6.425574e-01, 48,6.406624e-01,
+ 49,6.350314e-01, 50,6.035584e-01, 51,7.096073e-01, 52,6.357595e-01, 53,7.486250e-01, 54,6.166499e-01, 55,6.072836e-01, 56,6.791634e-01,
+ 57,6.077466e-01, 58,5.997730e-01, 59,7.431227e-01, 60,6.945480e-01, 61,6.617120e-01, 62,7.136844e-01, 63,7.453401e-01, 64,6.460979e-01,
+ 65,6.530915e-01, 66,7.727995e-01, 67,7.534481e-01, 68,7.362186e-01, 69,5.927040e-01, 70,7.378715e-01, 71,6.248127e-01, 72,6.130282e-01,
+ 73,5.931736e-01, 74,7.055744e-01, 75,7.487390e-01, 76,6.306069e-01, 77,6.493056e-01, 78,6.044278e-01, 79,7.392298e-01, 80,5.893168e-01,
+ 81,7.515131e-01, 82,7.644561e-01, 83,6.316034e-01, 84,7.718083e-01, 85,6.300181e-01, 86,7.558193e-01, 87,6.073223e-01, 88,6.216432e-01,
+ 89,6.497294e-01, 90,6.187656e-01, 91,6.195924e-01, 92,6.422347e-01, 93,5.892756e-01, 94,6.414811e-01, 95,7.482514e-01, 96,7.434448e-01,
+ 97,7.427694e-01, 98,5.883394e-01, 99,6.280384e-01, 100,6.052050e-01, 101,6.900588e-01, 102,6.163554e-01, 103,7.436584e-01, 104,6.018538e-01,
+ 105,6.428486e-01, 106,5.848571e-01, 107,6.493935e-01, 108,7.199861e-01, 109,6.132674e-01, 110,6.228260e-01, 111,7.657417e-01, 112,6.337030e-01,
+ 113,6.843182e-01, 114,6.492410e-01, 115,7.025174e-01, 116,6.447825e-01, 117,6.304465e-01, 118,6.607598e-01, 119,7.062064e-01, 120,6.576671e-01,
+ 121,7.633961e-01, 122,7.611492e-01, 123,5.953969e-01, 124,6.762479e-01, 125,7.259862e-01, 126,6.177943e-01, 127,7.659471e-01, 128,7.227094e-01,
+ 129,6.028339e-01, 130,7.122309e-01, 131,6.005699e-01, 132,6.886077e-01, 133,7.079255e-01, 134,7.204981e-01, 135,6.516894e-01, 136,6.315032e-01,
+ 137,6.074607e-01, 138,6.950842e-01, 139,6.122538e-01, 140,6.490932e-01, 141,6.147921e-01, 142,5.988569e-01, 143,6.406316e-01, 144,6.283549e-01,
+ 145,7.022147e-01, 146,6.580559e-01, 147,6.852877e-01, 148,6.237081e-01, 149,6.156871e-01, 150,6.652082e-01, 151,7.596526e-01, 152,7.352083e-01,
+ 153,6.178485e-01, 154,6.720802e-01, 155,6.993374e-01, 156,6.590339e-01, 157,7.617493e-01, 158,6.429681e-01, 159,6.620965e-01, 160,6.944186e-01,
+ 161,6.479814e-01, 162,6.041427e-01, 163,6.412895e-01, 164,7.437616e-01, 165,6.158905e-01, 166,7.705052e-01, 167,7.141258e-01, 168,7.045295e-01,
+ 169,7.182502e-01, 170,7.397370e-01, 171,6.667720e-01, 172,6.048062e-01, 173,6.455017e-01, 174,6.066242e-01, 175,6.983726e-01, 176,6.897260e-01,
+ 177,6.922821e-01, 178,7.619605e-01, 179,6.663551e-01, 180,6.631823e-01, 181,6.670724e-01, 182,6.807613e-01, 183,7.204481e-01, 184,7.536579e-01,
+ 185,6.671357e-01, 186,6.181179e-01, 187,6.716456e-01, 188,6.295696e-01, 189,6.729275e-01, 190,6.336696e-01, 191,7.403551e-01, 192,7.671503e-01,
+ 193,6.761872e-01, 194,6.094134e-01, 195,6.418973e-01, 196,7.531818e-01, 197,6.755496e-01, 198,6.296940e-01, 199,6.182713e-01, 200,7.601557e-01,
+ 201,6.037724e-01, 202,7.270045e-01, 203,7.155135e-01, 204,7.056435e-01, 205,6.024429e-01, 206,6.378875e-01, 207,6.534129e-01, 208,7.285378e-01,
+ 209,7.075489e-01, 210,6.960255e-01, 211,7.240333e-01, 212,6.815748e-01, 213,7.327339e-01, 214,6.566524e-01, 215,7.242635e-01, 216,7.636026e-01,
+ 217,6.856345e-01, 218,6.366410e-01, 219,7.349502e-01, 220,6.298851e-01, 221,6.879987e-01, 222,7.060987e-01, 223,7.077338e-01, 224,6.752781e-01,
+ 225,6.308225e-01, 226,6.271528e-01, 227,7.674868e-01, 228,7.265644e-01, 229,6.374890e-01, 230,6.410935e-01, 231,6.377284e-01, 232,7.703143e-01,
+ 233,7.347211e-01, 234,7.175597e-01, 235,6.239247e-01, 236,6.507171e-01, 237,5.927601e-01, 238,6.556214e-01, 239,6.684277e-01, 240,6.745993e-01,
+ 241,6.191435e-01, 242,6.626489e-01, 243,7.135485e-01, 244,7.043486e-01, 245,5.850391e-01, 246,6.289304e-01, 247,6.568832e-01, 248,7.551936e-01,
+ 249,6.881967e-01, 250,6.740880e-01, 251,7.637849e-01, 252,7.568751e-01, 253,7.882884e-01, 254,5.825963e-01, 255,7.882884e-01, 256,5.825963e-01,
+ 257,7.573752e-01, 258,7.882884e-01, 259,7.882884e-01)
.param L4C=table(run, 1,2.365149e-13, 2,2.292006e-13, 3,1.963780e-13, 4,1.360555e-13, 5,1.913435e-13, 6,1.671793e-13, 7,2.355749e-13, 8,1.648217e-13,
+ 9,1.818203e-13, 10,2.059614e-13, 11,2.046517e-13, 12,2.137799e-13, 13,1.999422e-13, 14,1.404183e-13, 15,2.039622e-13, 16,1.732934e-13,
+ 17,1.637633e-13, 18,1.865770e-13, 19,2.241248e-13, 20,1.651057e-13, 21,1.735310e-13, 22,1.671497e-13, 23,1.714580e-13, 24,1.783561e-13,
+ 25,2.028760e-13, 26,2.224244e-13, 27,2.211793e-13, 28,1.847714e-13, 29,1.700635e-13, 30,1.947194e-13, 31,2.465385e-13, 32,1.850501e-13,
+ 33,1.885283e-13, 34,2.265262e-13, 35,1.516901e-13, 36,1.664944e-13, 37,1.854329e-13, 38,1.879386e-13, 39,1.982988e-13, 40,1.960161e-13,
+ 41,1.665038e-13, 42,2.103733e-13, 43,1.685644e-13, 44,1.997102e-13, 45,1.601063e-13, 46,1.572294e-13, 47,1.708672e-13, 48,1.785444e-13,
+ 49,1.728873e-13, 50,2.051781e-13, 51,1.764381e-13, 52,1.319755e-13, 53,2.162973e-13, 54,2.302599e-13, 55,2.319536e-13, 56,2.396491e-13,
+ 57,1.879526e-13, 58,1.681345e-13, 59,1.685113e-13, 60,2.365744e-13, 61,2.033382e-13, 62,1.818651e-13, 63,1.981714e-13, 64,1.452625e-13,
+ 65,2.033673e-13, 66,1.741955e-13, 67,1.700621e-13, 68,1.660270e-13, 69,1.769553e-13, 70,1.956475e-13, 71,1.750911e-13, 72,1.916307e-13,
+ 73,2.044037e-13, 74,2.241843e-13, 75,2.232193e-13, 76,1.989472e-13, 77,1.895875e-13, 78,1.850001e-13, 79,2.133865e-13, 80,2.012357e-13,
+ 81,1.583331e-13, 82,1.865609e-13, 83,1.831155e-13, 84,1.819507e-13, 85,1.982334e-13, 86,2.001916e-13, 87,1.988322e-13, 88,1.635792e-13,
+ 89,2.196552e-13, 90,2.121165e-13, 91,1.876086e-13, 92,2.100884e-13, 93,1.852047e-13, 94,2.132058e-13, 95,1.600910e-13, 96,1.471318e-13,
+ 97,2.015659e-13, 98,2.097635e-13, 99,2.158545e-13, 100,1.690707e-13, 101,1.460330e-13, 102,2.335125e-13, 103,1.839943e-13, 104,1.706420e-13,
+ 105,2.056102e-13, 106,2.120203e-13, 107,1.380514e-13, 108,1.554388e-13, 109,1.843975e-13, 110,1.870352e-13, 111,1.724600e-13, 112,2.243515e-13,
+ 113,1.909690e-13, 114,1.680943e-13, 115,1.512615e-13, 116,1.348918e-13, 117,1.912380e-13, 118,1.700458e-13, 119,1.968315e-13, 120,1.869047e-13,
+ 121,1.596841e-13, 122,1.907890e-13, 123,1.914549e-13, 124,1.763914e-13, 125,1.796262e-13, 126,1.819574e-13, 127,1.618517e-13, 128,1.714968e-13,
+ 129,1.597305e-13, 130,2.047106e-13, 131,1.330972e-13, 132,1.556215e-13, 133,1.908296e-13, 134,1.653299e-13, 135,1.678925e-13, 136,1.498119e-13,
+ 137,1.679848e-13, 138,1.980815e-13, 139,2.369146e-13, 140,2.334617e-13, 141,1.464288e-13, 142,2.118014e-13, 143,2.097364e-13, 144,2.022310e-13,
+ 145,2.020284e-13, 146,1.815525e-13, 147,2.268881e-13, 148,1.671133e-13, 149,1.455288e-13, 150,2.076678e-13, 151,1.812598e-13, 152,2.329685e-13,
+ 153,1.990181e-13, 154,1.618204e-13, 155,1.671409e-13, 156,1.465965e-13, 157,2.095964e-13, 158,1.775822e-13, 159,1.961278e-13, 160,1.475581e-13,
+ 161,1.771037e-13, 162,1.402791e-13, 163,2.448912e-13, 164,1.870414e-13, 165,1.807461e-13, 166,1.605019e-13, 167,2.086029e-13, 168,2.238404e-13,
+ 169,1.846090e-13, 170,2.291441e-13, 171,2.473561e-13, 172,2.010284e-13, 173,2.158141e-13, 174,1.619660e-13, 175,1.835670e-13, 176,1.472562e-13,
+ 177,2.047804e-13, 178,1.614129e-13, 179,1.963197e-13, 180,2.119594e-13, 181,1.990381e-13, 182,1.598848e-13, 183,2.138349e-13, 184,1.730818e-13,
+ 185,2.096203e-13, 186,2.049476e-13, 187,2.167943e-13, 188,2.034916e-13, 189,1.654699e-13, 190,2.246521e-13, 191,1.414725e-13, 192,2.085031e-13,
+ 193,1.610567e-13, 194,2.074713e-13, 195,2.216980e-13, 196,1.834487e-13, 197,2.049177e-13, 198,1.773174e-13, 199,2.495421e-13, 200,1.880723e-13,
+ 201,1.361273e-13, 202,1.867020e-13, 203,2.426157e-13, 204,1.993665e-13, 205,1.596382e-13, 206,2.037361e-13, 207,1.675573e-13, 208,2.481414e-13,
+ 209,2.270641e-13, 210,1.819043e-13, 211,1.711066e-13, 212,1.850055e-13, 213,1.903467e-13, 214,2.075339e-13, 215,2.158699e-13, 216,1.513782e-13,
+ 217,1.866336e-13, 218,1.781457e-13, 219,2.129429e-13, 220,1.969530e-13, 221,1.821308e-13, 222,1.720442e-13, 223,2.020862e-13, 224,1.968039e-13,
+ 225,2.074378e-13, 226,2.151375e-13, 227,1.871794e-13, 228,1.758438e-13, 229,2.207810e-13, 230,1.521951e-13, 231,2.197863e-13, 232,1.853940e-13,
+ 233,1.633803e-13, 234,2.139915e-13, 235,2.355158e-13, 236,2.025123e-13, 237,2.467937e-13, 238,1.680842e-13, 239,2.134232e-13, 240,1.700906e-13,
+ 241,2.016703e-13, 242,2.099838e-13, 243,1.856473e-13, 244,1.607351e-13, 245,1.876612e-13, 246,1.867499e-13, 247,1.968477e-13, 248,1.525907e-13,
+ 249,1.618055e-13, 250,1.931260e-13, 251,1.523361e-13, 252,1.604689e-13, 253,2.592006e-13, 254,1.303639e-13, 255,2.592006e-13, 256,2.665149e-13,
+ 257,1.303639e-13, 258,2.592006e-13, 259,2.592006e-13)
.param L4Ltr=table(run, 1,1.000000e-09, 2,1.000000e-09, 3,1.457260e-09, 4,9.529343e-10, 5,1.281719e-09, 6,1.764754e-09, 7,1.161753e-09, 8,9.407964e-10,
+ 9,1.403164e-09, 10,1.914138e-09, 11,1.106958e-09, 12,9.337050e-10, 13,1.281968e-09, 14,1.477591e-09, 15,6.584609e-10, 16,1.051458e-09,
+ 17,1.297986e-09, 18,8.958620e-10, 19,1.810635e-09, 20,1.893910e-09, 21,1.759972e-09, 22,9.936689e-10, 23,1.278600e-09, 24,7.345994e-10,
+ 25,7.889331e-10, 26,7.941638e-10, 27,1.515947e-09, 28,5.653469e-10, 29,1.513790e-09, 30,1.051776e-09, 31,9.500612e-10, 32,1.601948e-09,
+ 33,6.282090e-10, 34,1.726813e-09, 35,8.646504e-10, 36,1.607907e-09, 37,1.501315e-09, 38,1.941188e-09, 39,5.922770e-10, 40,1.597453e-09,
+ 41,1.525814e-09, 42,1.884173e-09, 43,9.458190e-10, 44,1.500408e-09, 45,1.609462e-09, 46,1.459683e-09, 47,6.644702e-10, 48,5.692568e-10,
+ 49,1.522074e-09, 50,1.205819e-09, 51,1.747638e-09, 52,7.234170e-10, 53,1.250636e-09, 54,1.097144e-09, 55,1.212144e-09, 56,1.100586e-09,
+ 57,1.936696e-09, 58,1.582711e-09, 59,1.511159e-09, 60,1.723743e-09, 61,1.387916e-09, 62,1.707416e-09, 63,1.923379e-09, 64,5.416169e-10,
+ 65,1.526560e-09, 66,1.924800e-09, 67,7.168183e-10, 68,1.025261e-09, 69,5.869846e-10, 70,1.518957e-09, 71,8.525303e-10, 72,1.841181e-09,
+ 73,1.739886e-09, 74,1.415439e-09, 75,1.597892e-09, 76,6.020379e-10, 77,1.564613e-09, 78,1.219522e-09, 79,7.724635e-10, 80,1.701281e-09,
+ 81,1.350623e-09, 82,1.135407e-09, 83,5.414411e-10, 84,1.231017e-09, 85,9.971648e-10, 86,1.542285e-09, 87,5.671343e-10, 88,1.572942e-09,
+ 89,1.429822e-09, 90,1.505594e-09, 91,8.466809e-10, 92,1.126201e-09, 93,1.919395e-09, 94,5.276550e-10, 95,1.508968e-09, 96,1.743939e-09,
+ 97,5.224999e-10, 98,1.802920e-09, 99,7.659078e-10, 100,1.909476e-09, 101,6.792808e-10, 102,1.709002e-09, 103,1.386280e-09, 104,5.634656e-10,
+ 105,1.208092e-09, 106,1.864274e-09, 107,1.895970e-09, 108,1.184746e-09, 109,5.605328e-10, 110,7.068634e-10, 111,1.316639e-09, 112,1.905317e-09,
+ 113,1.424573e-09, 114,1.294380e-09, 115,1.888221e-09, 116,5.455715e-10, 117,8.915868e-10, 118,1.316800e-09, 119,1.261874e-09, 120,1.229318e-09,
+ 121,1.927851e-09, 122,1.765076e-09, 123,6.388299e-10, 124,1.103969e-09, 125,1.492433e-09, 126,8.853253e-10, 127,1.391687e-09, 128,5.013374e-10,
+ 129,1.954277e-09, 130,9.310991e-10, 131,9.918467e-10, 132,1.036454e-09, 133,1.014864e-09, 134,9.092679e-10, 135,8.845526e-10, 136,1.053867e-09,
+ 137,6.384950e-10, 138,1.101236e-09, 139,1.572270e-09, 140,5.164347e-10, 141,1.534654e-09, 142,9.768275e-10, 143,1.663346e-09, 144,7.752853e-10,
+ 145,9.550693e-10, 146,1.699099e-09, 147,1.093387e-09, 148,1.652914e-09, 149,9.098072e-10, 150,8.836023e-10, 151,1.582806e-09, 152,1.765142e-09,
+ 153,1.716001e-09, 154,8.233416e-10, 155,7.154231e-10, 156,1.006473e-09, 157,5.308087e-10, 158,7.613966e-10, 159,1.130950e-09, 160,1.034567e-09,
+ 161,1.313483e-09, 162,1.084179e-09, 163,1.035435e-09, 164,1.690441e-09, 165,1.296591e-09, 166,8.197726e-10, 167,8.852255e-10, 168,1.805575e-09,
+ 169,1.185637e-09, 170,1.643120e-09, 171,1.505191e-09, 172,1.944506e-09, 173,1.598748e-09, 174,1.493037e-09, 175,9.569726e-10, 176,1.709336e-09,
+ 177,1.914470e-09, 178,1.153199e-09, 179,1.332864e-09, 180,1.342597e-09, 181,1.795613e-09, 182,1.212108e-09, 183,5.163278e-10, 184,1.065555e-09,
+ 185,1.831051e-09, 186,1.780954e-09, 187,5.864244e-10, 188,8.906333e-10, 189,1.954326e-09, 190,1.777959e-09, 191,7.525328e-10, 192,1.428078e-09,
+ 193,1.680501e-09, 194,7.269077e-10, 195,1.483752e-09, 196,1.788658e-09, 197,8.098850e-10, 198,1.100372e-09, 199,1.363919e-09, 200,7.331950e-10,
+ 201,1.899992e-09, 202,1.127639e-09, 203,7.901083e-10, 204,1.636184e-09, 205,1.730597e-09, 206,5.327797e-10, 207,1.194140e-09, 208,1.375768e-09,
+ 209,1.426227e-09, 210,1.156049e-09, 211,9.454193e-10, 212,1.113355e-09, 213,1.854207e-09, 214,5.694475e-10, 215,1.282318e-09, 216,1.160442e-09,
+ 217,1.016066e-09, 218,1.004678e-09, 219,1.420198e-09, 220,1.420630e-09, 221,8.133970e-10, 222,1.304102e-09, 223,1.655385e-09, 224,1.440738e-09,
+ 225,1.955573e-09, 226,1.977701e-09, 227,6.007731e-10, 228,1.800320e-09, 229,9.843177e-10, 230,1.010902e-09, 231,1.426282e-09, 232,1.242718e-09,
+ 233,9.933808e-10, 234,7.556077e-10, 235,5.001596e-10, 236,1.528864e-09, 237,1.723491e-09, 238,1.093053e-09, 239,1.619321e-09, 240,1.637546e-09,
+ 241,7.196838e-10, 242,6.411533e-10, 243,1.863266e-09, 244,1.399353e-09, 245,5.278249e-10, 246,1.836130e-09, 247,1.213319e-09, 248,1.667744e-09,
+ 249,1.393782e-09, 250,7.051655e-10, 251,1.993914e-09, 252,1.977728e-09, 253,2.000000e-09, 254,5.000000e-10, 255,5.000000e-10, 256,2.000000e-09,
+ 257,5.000000e-10, 258,2.000000e-09, 259,2.000000e-09)
.param L6L=table(run, 1,6.664000e-08, 2,6.936000e-08, 3,6.849505e-08, 4,6.762152e-08, 5,6.900786e-08, 6,6.704742e-08, 7,6.894469e-08, 8,6.666550e-08,
+ 9,6.757284e-08, 10,6.830238e-08, 11,6.711679e-08, 12,6.924188e-08, 13,6.771361e-08, 14,6.711801e-08, 15,6.672588e-08, 16,6.932234e-08,
+ 17,6.851505e-08, 18,6.818629e-08, 19,6.898347e-08, 20,6.734863e-08, 21,6.903186e-08, 22,6.679337e-08, 23,6.744819e-08, 24,6.795559e-08,
+ 25,6.848856e-08, 26,6.768023e-08, 27,6.904908e-08, 28,6.714864e-08, 29,6.765758e-08, 30,6.922117e-08, 31,6.686884e-08, 32,6.671609e-08,
+ 33,6.665949e-08, 34,6.790979e-08, 35,6.705457e-08, 36,6.792040e-08, 37,6.926042e-08, 38,6.755167e-08, 39,6.745034e-08, 40,6.670825e-08,
+ 41,6.725670e-08, 42,6.885297e-08, 43,6.751244e-08, 44,6.795542e-08, 45,6.690695e-08, 46,6.786955e-08, 47,6.681894e-08, 48,6.771631e-08,
+ 49,6.688353e-08, 50,6.934111e-08, 51,6.735715e-08, 52,6.700065e-08, 53,6.882875e-08, 54,6.781199e-08, 55,6.750643e-08, 56,6.706452e-08,
+ 57,6.779385e-08, 58,6.788105e-08, 59,6.874030e-08, 60,6.724073e-08, 61,6.883705e-08, 62,6.806919e-08, 63,6.670444e-08, 64,6.759836e-08,
+ 65,6.700967e-08, 66,6.868506e-08, 67,6.836788e-08, 68,6.908312e-08, 69,6.722460e-08, 70,6.721616e-08, 71,6.705217e-08, 72,6.828578e-08,
+ 73,6.668340e-08, 74,6.781962e-08, 75,6.866745e-08, 76,6.707435e-08, 77,6.848339e-08, 78,6.920188e-08, 79,6.686979e-08, 80,6.896720e-08,
+ 81,6.785957e-08, 82,6.885680e-08, 83,6.886576e-08, 84,6.850194e-08, 85,6.931760e-08, 86,6.809308e-08, 87,6.930001e-08, 88,6.721394e-08,
+ 89,6.732675e-08, 90,6.786602e-08, 91,6.667537e-08, 92,6.825198e-08, 93,6.919159e-08, 94,6.754030e-08, 95,6.738687e-08, 96,6.727589e-08,
+ 97,6.830630e-08, 98,6.906142e-08, 99,6.737882e-08, 100,6.687194e-08, 101,6.933762e-08, 102,6.790247e-08, 103,6.759750e-08, 104,6.681149e-08,
+ 105,6.811351e-08, 106,6.891404e-08, 107,6.932843e-08, 108,6.685541e-08, 109,6.805358e-08, 110,6.733438e-08, 111,6.817780e-08, 112,6.875389e-08,
+ 113,6.842240e-08, 114,6.759698e-08, 115,6.695957e-08, 116,6.759405e-08, 117,6.891276e-08, 118,6.902133e-08, 119,6.708873e-08, 120,6.917351e-08,
+ 121,6.745064e-08, 122,6.717783e-08, 123,6.734809e-08, 124,6.853745e-08, 125,6.870431e-08, 126,6.771961e-08, 127,6.715268e-08, 128,6.728152e-08,
+ 129,6.875756e-08, 130,6.675543e-08, 131,6.838982e-08, 132,6.790206e-08, 133,6.784037e-08, 134,6.778844e-08, 135,6.855358e-08, 136,6.895639e-08,
+ 137,6.693298e-08, 138,6.714096e-08, 139,6.907693e-08, 140,6.831290e-08, 141,6.825378e-08, 142,6.846778e-08, 143,6.841019e-08, 144,6.690659e-08,
+ 145,6.852445e-08, 146,6.864461e-08, 147,6.744783e-08, 148,6.674640e-08, 149,6.865664e-08, 150,6.914310e-08, 151,6.881996e-08, 152,6.860353e-08,
+ 153,6.711779e-08, 154,6.853568e-08, 155,6.895683e-08, 156,6.853182e-08, 157,6.878404e-08, 158,6.777001e-08, 159,6.729444e-08, 160,6.837275e-08,
+ 161,6.676694e-08, 162,6.778752e-08, 163,6.861723e-08, 164,6.736939e-08, 165,6.800330e-08, 166,6.870554e-08, 167,6.813215e-08, 168,6.785229e-08,
+ 169,6.804682e-08, 170,6.806041e-08, 171,6.706028e-08, 172,6.687138e-08, 173,6.679574e-08, 174,6.856266e-08, 175,6.845584e-08, 176,6.724201e-08,
+ 177,6.801999e-08, 178,6.869899e-08, 179,6.795747e-08, 180,6.887695e-08, 181,6.813733e-08, 182,6.808347e-08, 183,6.922943e-08, 184,6.877723e-08,
+ 185,6.885356e-08, 186,6.797345e-08, 187,6.877501e-08, 188,6.686704e-08, 189,6.790520e-08, 190,6.912536e-08, 191,6.757808e-08, 192,6.841059e-08,
+ 193,6.670268e-08, 194,6.699039e-08, 195,6.690154e-08, 196,6.844025e-08, 197,6.819967e-08, 198,6.772840e-08, 199,6.872653e-08, 200,6.754734e-08,
+ 201,6.710096e-08, 202,6.717542e-08, 203,6.874281e-08, 204,6.730440e-08, 205,6.880948e-08, 206,6.796684e-08, 207,6.818859e-08, 208,6.694833e-08,
+ 209,6.717520e-08, 210,6.778908e-08, 211,6.841492e-08, 212,6.677352e-08, 213,6.886043e-08, 214,6.901989e-08, 215,6.882342e-08, 216,6.861086e-08,
+ 217,6.723333e-08, 218,6.820200e-08, 219,6.769017e-08, 220,6.844829e-08, 221,6.908367e-08, 222,6.803042e-08, 223,6.923133e-08, 224,6.928112e-08,
+ 225,6.670885e-08, 226,6.707331e-08, 227,6.729834e-08, 228,6.840442e-08, 229,6.715988e-08, 230,6.883413e-08, 231,6.820255e-08, 232,6.713706e-08,
+ 233,6.810929e-08, 234,6.914265e-08, 235,6.671744e-08, 236,6.793069e-08, 237,6.893568e-08, 238,6.879767e-08, 239,6.913135e-08, 240,6.711088e-08,
+ 241,6.688320e-08, 242,6.777922e-08, 243,6.816022e-08, 244,6.876355e-08, 245,6.867666e-08, 246,6.752822e-08, 247,6.791945e-08, 248,6.709082e-08,
+ 249,6.704029e-08, 250,6.866680e-08, 251,6.923492e-08, 252,6.743512e-08, 253,6.936000e-08, 254,6.664000e-08, 255,6.664000e-08, 256,6.664000e-08,
+ 257,6.664000e-08, 258,6.664000e-08, 259,6.936000e-08)
.param L6R=table(run, 1,6.280672e-01, 2,6.537026e-01, 3,5.843891e-01, 4,6.365367e-01, 5,5.389202e-01, 6,5.498158e-01, 7,6.216043e-01, 8,4.889104e-01,
+ 9,6.322175e-01, 10,6.315375e-01, 11,5.904111e-01, 12,5.030368e-01, 13,5.806640e-01, 14,5.214710e-01, 15,4.998459e-01, 16,5.579890e-01,
+ 17,5.990621e-01, 18,5.098397e-01, 19,5.239340e-01, 20,5.325687e-01, 21,5.834053e-01, 22,5.178134e-01, 23,5.659212e-01, 24,5.283549e-01,
+ 25,6.039322e-01, 26,5.503052e-01, 27,6.280603e-01, 28,5.372077e-01, 29,5.125406e-01, 30,6.330221e-01, 31,4.960071e-01, 32,5.188207e-01,
+ 33,6.083998e-01, 34,5.285622e-01, 35,5.983000e-01, 36,5.042407e-01, 37,5.665413e-01, 38,4.944812e-01, 39,6.263936e-01, 40,5.039341e-01,
+ 41,5.191789e-01, 42,6.484590e-01, 43,5.070570e-01, 44,5.044949e-01, 45,5.475408e-01, 46,6.104642e-01, 47,5.150148e-01, 48,6.265719e-01,
+ 49,5.945589e-01, 50,5.321518e-01, 51,5.536295e-01, 52,6.142715e-01, 53,5.927860e-01, 54,5.375077e-01, 55,5.590002e-01, 56,5.649779e-01,
+ 57,5.870159e-01, 58,6.271022e-01, 59,5.451507e-01, 60,4.936378e-01, 61,6.362881e-01, 62,5.510296e-01, 63,5.044092e-01, 64,6.175943e-01,
+ 65,5.166849e-01, 66,5.329944e-01, 67,5.053605e-01, 68,5.764052e-01, 69,5.422034e-01, 70,5.010346e-01, 71,5.449594e-01, 72,6.403607e-01,
+ 73,5.876904e-01, 74,5.131657e-01, 75,5.770532e-01, 76,5.951067e-01, 77,5.947685e-01, 78,5.074096e-01, 79,5.620747e-01, 80,6.197547e-01,
+ 81,4.994876e-01, 82,5.264581e-01, 83,5.471159e-01, 84,5.090808e-01, 85,5.419742e-01, 86,6.119448e-01, 87,6.337354e-01, 88,5.103712e-01,
+ 89,4.906098e-01, 90,5.286767e-01, 91,4.994464e-01, 92,5.853220e-01, 93,5.075265e-01, 94,4.922147e-01, 95,5.069341e-01, 96,5.229850e-01,
+ 97,6.299043e-01, 98,5.045471e-01, 99,5.900775e-01, 100,6.104544e-01, 101,5.268369e-01, 102,5.480103e-01, 103,5.174154e-01, 104,5.415032e-01,
+ 105,5.438012e-01, 106,5.239372e-01, 107,5.920937e-01, 108,5.872817e-01, 109,5.532081e-01, 110,5.228410e-01, 111,5.746723e-01, 112,5.114730e-01,
+ 113,4.993347e-01, 114,4.903877e-01, 115,5.707272e-01, 116,6.305743e-01, 117,6.233288e-01, 118,6.329842e-01, 119,5.167243e-01, 120,5.371656e-01,
+ 121,5.465111e-01, 122,5.357997e-01, 123,5.926128e-01, 124,6.114766e-01, 125,6.216835e-01, 126,5.041837e-01, 127,5.697334e-01, 128,6.299639e-01,
+ 129,5.338787e-01, 130,4.860648e-01, 131,5.111311e-01, 132,5.212289e-01, 133,6.271136e-01, 134,5.440474e-01, 135,5.178175e-01, 136,5.455986e-01,
+ 137,5.308820e-01, 138,4.950451e-01, 139,5.961274e-01, 140,5.986613e-01, 141,5.609196e-01, 142,6.088615e-01, 143,6.266295e-01, 144,5.519341e-01,
+ 145,5.420617e-01, 146,5.356174e-01, 147,5.133704e-01, 148,5.543792e-01, 149,5.155438e-01, 150,5.150716e-01, 151,5.077885e-01, 152,5.131945e-01,
+ 153,5.018792e-01, 154,6.206211e-01, 155,5.224762e-01, 156,4.982179e-01, 157,5.666595e-01, 158,4.970874e-01, 159,5.755651e-01, 160,5.683567e-01,
+ 161,5.618233e-01, 162,5.416629e-01, 163,5.311451e-01, 164,5.491787e-01, 165,5.714176e-01, 166,5.168280e-01, 167,5.611615e-01, 168,5.168347e-01,
+ 169,6.240951e-01, 170,5.289160e-01, 171,5.312860e-01, 172,5.654977e-01, 173,5.309382e-01, 174,5.374308e-01, 175,5.245907e-01, 176,5.753491e-01,
+ 177,4.952304e-01, 178,6.278095e-01, 179,5.941823e-01, 180,6.259232e-01, 181,5.760538e-01, 182,5.073491e-01, 183,6.069704e-01, 184,6.008045e-01,
+ 185,5.271136e-01, 186,5.132372e-01, 187,5.994243e-01, 188,4.970854e-01, 189,6.014884e-01, 190,5.842333e-01, 191,6.292407e-01, 192,5.978234e-01,
+ 193,4.906945e-01, 194,5.309558e-01, 195,5.899389e-01, 196,5.312403e-01, 197,6.044880e-01, 198,5.670939e-01, 199,6.152419e-01, 200,5.089951e-01,
+ 201,5.318167e-01, 202,5.081465e-01, 203,5.855017e-01, 204,6.274243e-01, 205,5.419633e-01, 206,6.348082e-01, 207,6.176902e-01, 208,5.357709e-01,
+ 209,5.854378e-01, 210,6.089788e-01, 211,5.290935e-01, 212,5.766868e-01, 213,5.347420e-01, 214,5.068134e-01, 215,5.457970e-01, 216,6.328943e-01,
+ 217,4.899868e-01, 218,5.134154e-01, 219,5.951678e-01, 220,5.396122e-01, 221,5.417395e-01, 222,6.123178e-01, 223,5.552582e-01, 224,5.219520e-01,
+ 225,5.076108e-01, 226,5.917072e-01, 227,6.160598e-01, 228,5.942870e-01, 229,5.267320e-01, 230,5.213924e-01, 231,6.291528e-01, 232,6.223685e-01,
+ 233,5.571402e-01, 234,5.759569e-01, 235,5.622425e-01, 236,5.521065e-01, 237,5.335790e-01, 238,5.281571e-01, 239,5.494956e-01, 240,4.989979e-01,
+ 241,5.484900e-01, 242,4.964895e-01, 243,6.041030e-01, 244,6.240283e-01, 245,5.673269e-01, 246,6.261037e-01, 247,5.108244e-01, 248,5.470152e-01,
+ 249,5.706924e-01, 250,5.696225e-01, 251,5.482800e-01, 252,6.276751e-01, 253,6.537026e-01, 254,4.831286e-01, 255,4.831286e-01, 256,4.831286e-01,
+ 257,6.280672e-01, 258,6.280672e-01, 259,6.537026e-01)
.param L6C=table(run, 1,2.189362e-13, 2,2.123113e-13, 3,1.335505e-13, 4,1.563988e-13, 5,1.193240e-13, 6,2.272637e-13, 7,1.600015e-13, 8,2.331697e-13,
+ 9,2.010932e-13, 10,2.146157e-13, 11,1.786859e-13, 12,1.216084e-13, 13,1.426715e-13, 14,2.142652e-13, 15,1.547493e-13, 16,1.879843e-13,
+ 17,1.634679e-13, 18,1.818239e-13, 19,1.896995e-13, 20,2.189972e-13, 21,1.626574e-13, 22,1.524394e-13, 23,1.774352e-13, 24,1.518410e-13,
+ 25,1.613173e-13, 26,1.615851e-13, 27,1.594965e-13, 28,1.361069e-13, 29,1.724026e-13, 30,1.832675e-13, 31,1.386582e-13, 32,1.710639e-13,
+ 33,1.924218e-13, 34,1.640983e-13, 35,1.790241e-13, 36,1.946531e-13, 37,1.972682e-13, 38,2.015002e-13, 39,1.604050e-13, 40,1.816917e-13,
+ 41,2.316396e-13, 42,1.593321e-13, 43,1.831840e-13, 44,1.749754e-13, 45,2.133237e-13, 46,2.187303e-13, 47,1.719899e-13, 48,1.984938e-13,
+ 49,1.688942e-13, 50,1.701987e-13, 51,1.716113e-13, 52,1.589870e-13, 53,1.642949e-13, 54,1.485096e-13, 55,1.414308e-13, 56,1.584499e-13,
+ 57,1.784427e-13, 58,1.600900e-13, 59,1.881875e-13, 60,1.834955e-13, 61,1.435889e-13, 62,1.664260e-13, 63,1.674383e-13, 64,1.966815e-13,
+ 65,1.659192e-13, 66,2.020936e-13, 67,1.508238e-13, 68,2.257312e-13, 69,1.614243e-13, 70,1.927239e-13, 71,1.680536e-13, 72,1.651871e-13,
+ 73,2.034434e-13, 74,1.474226e-13, 75,1.875600e-13, 76,1.929444e-13, 77,1.669878e-13, 78,1.693952e-13, 79,1.985483e-13, 80,1.564814e-13,
+ 81,1.837826e-13, 82,1.633125e-13, 83,2.007908e-13, 84,1.683358e-13, 85,2.070464e-13, 86,1.259014e-13, 87,1.878680e-13, 88,1.668416e-13,
+ 89,1.762841e-13, 90,1.668117e-13, 91,1.537563e-13, 92,1.577546e-13, 93,1.642626e-13, 94,1.566922e-13, 95,1.755552e-13, 96,2.415171e-13,
+ 97,1.598286e-13, 98,2.072831e-13, 99,2.153912e-13, 100,1.805933e-13, 101,1.745773e-13, 102,2.269477e-13, 103,2.074286e-13, 104,1.773565e-13,
+ 105,1.708998e-13, 106,1.574885e-13, 107,1.797756e-13, 108,1.869964e-13, 109,1.412036e-13, 110,1.801994e-13, 111,1.527871e-13, 112,1.330099e-13,
+ 113,1.994997e-13, 114,1.503603e-13, 115,1.463113e-13, 116,2.003185e-13, 117,1.574989e-13, 118,2.029277e-13, 119,1.329145e-13, 120,1.659073e-13,
+ 121,1.919289e-13, 122,2.357871e-13, 123,2.276711e-13, 124,1.641335e-13, 125,1.402440e-13, 126,1.666191e-13, 127,1.903517e-13, 128,1.839410e-13,
+ 129,1.472094e-13, 130,1.771432e-13, 131,1.636637e-13, 132,1.412647e-13, 133,1.363070e-13, 134,1.964199e-13, 135,1.652787e-13, 136,2.102192e-13,
+ 137,1.632720e-13, 138,2.173668e-13, 139,1.704190e-13, 140,1.547130e-13, 141,1.931324e-13, 142,1.645312e-13, 143,1.640000e-13, 144,2.445615e-13,
+ 145,2.059280e-13, 146,1.885760e-13, 147,1.497560e-13, 148,1.866665e-13, 149,1.853096e-13, 150,1.698086e-13, 151,2.035476e-13, 152,1.684400e-13,
+ 153,1.320121e-13, 154,1.733161e-13, 155,1.899290e-13, 156,1.774156e-13, 157,1.664025e-13, 158,1.522360e-13, 159,1.441713e-13, 160,1.218257e-13,
+ 161,2.049227e-13, 162,1.766016e-13, 163,1.689478e-13, 164,1.592232e-13, 165,1.669350e-13, 166,2.162570e-13, 167,1.686369e-13, 168,1.431346e-13,
+ 169,2.170390e-13, 170,1.624792e-13, 171,1.781925e-13, 172,2.104791e-13, 173,2.028396e-13, 174,1.656173e-13, 175,1.574554e-13, 176,1.362446e-13,
+ 177,1.832207e-13, 178,1.436566e-13, 179,1.808604e-13, 180,1.292988e-13, 181,1.984558e-13, 182,1.705034e-13, 183,1.539089e-13, 184,2.347843e-13,
+ 185,1.617783e-13, 186,1.969611e-13, 187,1.618941e-13, 188,1.558223e-13, 189,1.819206e-13, 190,1.885903e-13, 191,2.231788e-13, 192,2.291115e-13,
+ 193,1.616259e-13, 194,1.773067e-13, 195,2.329438e-13, 196,1.738864e-13, 197,1.939625e-13, 198,1.738716e-13, 199,1.301337e-13, 200,1.530068e-13,
+ 201,1.875753e-13, 202,1.518657e-13, 203,1.626573e-13, 204,1.508230e-13, 205,1.441639e-13, 206,1.952752e-13, 207,1.828396e-13, 208,1.375214e-13,
+ 209,1.603283e-13, 210,1.815783e-13, 211,1.738702e-13, 212,1.704776e-13, 213,1.459654e-13, 214,1.762447e-13, 215,1.563686e-13, 216,1.816444e-13,
+ 217,1.997536e-13, 218,1.530633e-13, 219,1.522395e-13, 220,1.524944e-13, 221,1.307470e-13, 222,1.555341e-13, 223,1.748611e-13, 224,1.723462e-13,
+ 225,1.485263e-13, 226,1.866091e-13, 227,1.860387e-13, 228,1.929300e-13, 229,1.548464e-13, 230,2.333229e-13, 231,1.835581e-13, 232,1.866174e-13,
+ 233,1.567261e-13, 234,2.216262e-13, 235,1.288741e-13, 236,2.339872e-13, 237,2.350154e-13, 238,1.691214e-13, 239,1.628885e-13, 240,1.874151e-13,
+ 241,2.087520e-13, 242,1.897138e-13, 243,2.302511e-13, 244,1.859639e-13, 245,2.276364e-13, 246,1.548669e-13, 247,1.675206e-13, 248,1.567767e-13,
+ 249,1.620357e-13, 250,1.378712e-13, 251,1.699024e-13, 252,1.519599e-13, 253,2.423113e-13, 254,1.199623e-13, 255,1.199623e-13, 256,2.489362e-13,
+ 257,1.199623e-13, 258,1.199623e-13, 259,2.423113e-13)
.param L6Ltr=table(run, 1,1.000000e-09, 2,1.000000e-09, 3,1.556990e-09, 4,1.364995e-09, 5,1.958102e-09, 6,1.109651e-09, 7,7.743856e-10, 8,1.797944e-09,
+ 9,6.963901e-10, 10,1.673134e-09, 11,9.181497e-10, 12,1.427700e-09, 13,7.065340e-10, 14,1.295320e-09, 15,7.724625e-10, 16,5.703659e-10,
+ 17,6.839830e-10, 18,8.597685e-10, 19,1.684313e-09, 20,1.435536e-09, 21,1.971615e-09, 22,9.443157e-10, 23,1.585535e-09, 24,1.753436e-09,
+ 25,8.707100e-10, 26,1.328551e-09, 27,1.720361e-09, 28,1.112103e-09, 29,7.736477e-10, 30,1.441339e-09, 31,8.356428e-10, 32,1.044792e-09,
+ 33,9.413170e-10, 34,1.402032e-09, 35,1.512646e-09, 36,1.790712e-09, 37,1.050916e-09, 38,7.771726e-10, 39,1.239908e-09, 40,1.887287e-09,
+ 41,1.295049e-09, 42,9.877645e-10, 43,1.097131e-09, 44,1.684379e-09, 45,1.658576e-09, 46,6.386342e-10, 47,1.745092e-09, 48,1.162394e-09,
+ 49,6.176954e-10, 50,1.138906e-09, 51,7.346665e-10, 52,1.115887e-09, 53,1.264984e-09, 54,1.300958e-09, 55,7.795547e-10, 56,1.865506e-09,
+ 57,9.128649e-10, 58,1.636630e-09, 59,1.541944e-09, 60,6.741394e-10, 61,1.004296e-09, 62,1.825716e-09, 63,6.125997e-10, 64,1.400674e-09,
+ 65,8.683004e-10, 66,1.732002e-09, 67,1.298355e-09, 68,1.000724e-09, 69,1.611072e-09, 70,5.321634e-10, 71,7.250949e-10, 72,1.940668e-09,
+ 73,1.037970e-09, 74,6.183844e-10, 75,1.611052e-09, 76,1.588157e-09, 77,1.462898e-09, 78,1.353600e-09, 79,1.613924e-09, 80,1.283099e-09,
+ 81,1.742556e-09, 82,1.539210e-09, 83,1.743136e-09, 84,6.428556e-10, 85,7.471917e-10, 86,1.958344e-09, 87,1.907871e-09, 88,9.919190e-10,
+ 89,6.244486e-10, 90,1.558812e-09, 91,1.489590e-09, 92,1.085359e-09, 93,1.005788e-09, 94,5.811060e-10, 95,9.571549e-10, 96,1.326677e-09,
+ 97,5.285627e-10, 98,1.924024e-09, 99,1.250574e-09, 100,1.413353e-09, 101,1.100039e-09, 102,1.827658e-09, 103,1.570832e-09, 104,1.691562e-09,
+ 105,9.303110e-10, 106,5.010613e-10, 107,9.719406e-10, 108,8.035533e-10, 109,5.515244e-10, 110,1.411785e-09, 111,5.456069e-10, 112,5.847172e-10,
+ 113,1.585121e-09, 114,5.637900e-10, 115,1.955352e-09, 116,1.251889e-09, 117,1.795036e-09, 118,1.627232e-09, 119,1.000500e-09, 120,1.835587e-09,
+ 121,1.305932e-09, 122,1.346888e-09, 123,1.343792e-09, 124,1.769037e-09, 125,1.000081e-09, 126,7.236664e-10, 127,5.151981e-10, 128,1.123312e-09,
+ 129,1.711679e-09, 130,8.586778e-10, 131,1.246538e-09, 132,1.248592e-09, 133,1.042356e-09, 134,1.170287e-09, 135,1.178966e-09, 136,1.473422e-09,
+ 137,9.343242e-10, 138,1.180265e-09, 139,1.297220e-09, 140,1.802155e-09, 141,1.948236e-09, 142,6.722603e-10, 143,1.946065e-09, 144,9.442924e-10,
+ 145,1.281624e-09, 146,1.830259e-09, 147,8.819819e-10, 148,7.278351e-10, 149,1.077587e-09, 150,1.659568e-09, 151,5.852585e-10, 152,1.253056e-09,
+ 153,8.294616e-10, 154,8.043640e-10, 155,1.835691e-09, 156,1.214695e-09, 157,7.334856e-10, 158,1.280383e-09, 159,9.971583e-10, 160,1.260872e-09,
+ 161,1.905674e-09, 162,1.834540e-09, 163,1.712138e-09, 164,7.967872e-10, 165,1.089725e-09, 166,1.198187e-09, 167,1.341611e-09, 168,1.466527e-09,
+ 169,1.322832e-09, 170,1.833274e-09, 171,1.912816e-09, 172,7.894835e-10, 173,6.024400e-10, 174,1.940107e-09, 175,1.218428e-09, 176,6.988699e-10,
+ 177,1.086018e-09, 178,1.365350e-09, 179,7.843574e-10, 180,1.213301e-09, 181,6.212396e-10, 182,1.359675e-09, 183,1.660425e-09, 184,1.508225e-09,
+ 185,1.848590e-09, 186,1.767529e-09, 187,1.292544e-09, 188,9.154019e-10, 189,1.564286e-09, 190,6.076866e-10, 191,1.733735e-09, 192,6.648701e-10,
+ 193,1.399028e-09, 194,5.735655e-10, 195,5.352641e-10, 196,6.478161e-10, 197,1.121301e-09, 198,7.083104e-10, 199,1.386097e-09, 200,1.791338e-09,
+ 201,1.176232e-09, 202,7.337261e-10, 203,1.190339e-09, 204,1.094947e-09, 205,1.435534e-09, 206,1.255873e-09, 207,1.786808e-09, 208,1.109372e-09,
+ 209,1.012112e-09, 210,1.941366e-09, 211,1.235700e-09, 212,1.790695e-09, 213,5.810071e-10, 214,9.993212e-10, 215,7.255215e-10, 216,1.351812e-09,
+ 217,5.844275e-10, 218,1.391597e-09, 219,5.280502e-10, 220,5.144724e-10, 221,1.375737e-09, 222,1.641121e-09, 223,5.298302e-10, 224,1.653149e-09,
+ 225,8.340188e-10, 226,5.903964e-10, 227,1.062634e-09, 228,1.778434e-09, 229,1.473680e-09, 230,1.184701e-09, 231,6.930472e-10, 232,5.560661e-10,
+ 233,1.705777e-09, 234,5.652939e-10, 235,1.795975e-09, 236,1.597479e-09, 237,1.605556e-09, 238,1.868310e-09, 239,7.789438e-10, 240,7.537907e-10,
+ 241,1.108226e-09, 242,9.874800e-10, 243,1.537861e-09, 244,1.954043e-09, 245,1.467666e-09, 246,1.805985e-09, 247,1.844629e-09, 248,1.392983e-09,
+ 249,7.905267e-10, 250,8.897313e-10, 251,1.295275e-09, 252,1.925226e-09, 253,2.000000e-09, 254,5.000000e-10, 255,5.000000e-10, 256,2.000000e-09,
+ 257,5.000000e-10, 258,5.000000e-10, 259,2.000000e-09)
.param K24=table(run, 1,5.000000e-03, 2,5.000000e-03, 3,7.218611e-05, 4,4.653519e-03, 5,8.157566e-03, 6,-8.391608e-03, 7,-2.456888e-03, 8,-4.157663e-04,
+ 9,1.803775e-03, 10,3.495881e-03, 11,8.253822e-03, 12,5.320234e-03, 13,7.489214e-03, 14,-3.001921e-04, 15,4.890220e-03, 16,7.367254e-03,
+ 17,-1.462506e-03, 18,-6.673756e-03, 19,-7.981376e-03, 20,9.514667e-03, 21,1.824777e-05, 22,8.934106e-03, 23,4.027190e-03, 24,4.854702e-03,
+ 25,-4.636467e-04, 26,2.712337e-03, 27,9.234251e-03, 28,-9.776875e-03, 29,-4.293762e-03, 30,5.363414e-03, 31,-5.313628e-03, 32,4.442721e-03,
+ 33,6.424284e-03, 34,9.711434e-03, 35,8.061618e-03, 36,-9.027655e-05, 37,-7.749785e-03, 38,-1.063063e-03, 39,-9.130150e-03, 40,-2.741532e-03,
+ 41,1.885165e-04, 42,-4.351263e-03, 43,-9.531869e-03, 44,2.710288e-03, 45,6.232024e-03, 46,9.587096e-03, 47,2.171382e-03, 48,2.161671e-03,
+ 49,-3.107219e-03, 50,4.027137e-03, 51,1.268575e-03, 52,-3.335338e-03, 53,-9.044119e-03, 54,-9.542839e-03, 55,2.905249e-03, 56,5.775451e-03,
+ 57,2.321933e-03, 58,-6.784109e-03, 59,1.307718e-03, 60,-8.705669e-03, 61,5.354215e-03, 62,1.995184e-03, 63,-2.646539e-03, 64,9.397691e-03,
+ 65,-4.098952e-04, 66,-5.506811e-03, 67,4.910617e-03, 68,8.143193e-03, 69,8.729155e-03, 70,-6.984051e-03, 71,-8.987469e-04, 72,-4.252638e-03,
+ 73,-7.682366e-03, 74,4.240129e-04, 75,8.285456e-03, 76,-1.955116e-03, 77,8.659829e-03, 78,-5.410629e-03, 79,-3.037124e-03, 80,-3.912011e-03,
+ 81,-5.708822e-03, 82,1.704069e-03, 83,-4.079720e-03, 84,1.246744e-03, 85,-3.212691e-03, 86,6.801349e-03, 87,-4.606755e-03, 88,-5.097234e-03,
+ 89,3.425260e-03, 90,4.649105e-03, 91,-1.993020e-03, 92,9.564699e-03, 93,-9.508301e-03, 94,8.004903e-03, 95,8.656412e-03, 96,-3.828963e-03,
+ 97,-8.733905e-03, 98,3.054385e-03, 99,3.809811e-03, 100,2.985900e-03, 101,-7.044845e-03, 102,1.408368e-03, 103,2.440460e-03, 104,-3.819252e-04,
+ 105,-1.456499e-03, 106,-1.826408e-04, 107,-9.343865e-03, 108,-2.431586e-03, 109,-8.637522e-03, 110,-9.338632e-03, 111,8.596178e-03, 112,1.811224e-03,
+ 113,2.054148e-03, 114,-3.854704e-03, 115,2.622744e-03, 116,7.126280e-03, 117,-9.758176e-03, 118,9.141479e-03, 119,-5.177100e-03, 120,-6.482268e-03,
+ 121,8.993742e-03, 122,5.247718e-03, 123,-7.868768e-03, 124,4.031099e-03, 125,-5.629047e-03, 126,8.798770e-03, 127,-5.331298e-03, 128,-5.591562e-03,
+ 129,-9.399521e-03, 130,6.761389e-03, 131,-6.341149e-04, 132,9.353622e-03, 133,6.600206e-03, 134,-1.305613e-03, 135,-4.211849e-03, 136,8.901858e-03,
+ 137,-7.381148e-03, 138,9.206890e-03, 139,-2.212922e-03, 140,-7.887758e-03, 141,8.022088e-04, 142,-7.091983e-03, 143,-3.873511e-03, 144,7.147448e-03,
+ 145,9.415335e-03, 146,7.456217e-03, 147,-2.252642e-03, 148,-1.608212e-03, 149,-1.148640e-03, 150,-6.628766e-05, 151,8.706157e-03, 152,8.296098e-03,
+ 153,9.370325e-03, 154,-1.418995e-03, 155,-1.114241e-03, 156,1.621759e-03, 157,-5.414479e-04, 158,-4.377993e-03, 159,7.642543e-03, 160,-1.669845e-03,
+ 161,3.863374e-03, 162,-8.801347e-03, 163,-3.830170e-03, 164,-7.908949e-03, 165,-1.213356e-03, 166,-3.670101e-03, 167,5.750635e-03, 168,3.115724e-03,
+ 169,6.966967e-03, 170,4.798388e-03, 171,3.488889e-04, 172,7.453168e-03, 173,5.687103e-03, 174,4.713506e-03, 175,8.937764e-03, 176,1.869420e-03,
+ 177,-1.965588e-03, 178,-2.953405e-03, 179,3.055015e-03, 180,-7.777316e-03, 181,6.053843e-03, 182,-2.077116e-03, 183,6.589610e-03, 184,4.005771e-03,
+ 185,-4.961890e-03, 186,5.944581e-03, 187,-5.885193e-04, 188,-6.168706e-03, 189,6.986623e-04, 190,9.886150e-03, 191,-9.212711e-03, 192,-6.130902e-03,
+ 193,-4.396041e-03, 194,6.904987e-03, 195,9.689736e-03, 196,9.976831e-04, 197,-6.592737e-03, 198,9.135436e-03, 199,-7.517084e-03, 200,-2.210988e-03,
+ 201,8.274809e-03, 202,5.504143e-03, 203,1.459434e-03, 204,-5.858276e-03, 205,8.895132e-03, 206,8.583757e-03, 207,-8.628292e-03, 208,-8.609481e-03,
+ 209,-6.772137e-04, 210,-6.646609e-03, 211,-3.535445e-03, 212,5.682677e-03, 213,8.040624e-03, 214,5.790497e-03, 215,9.573219e-03, 216,-1.150183e-03,
+ 217,-5.520072e-03, 218,-8.937589e-03, 219,-6.368983e-03, 220,5.208715e-03, 221,-1.395909e-03, 222,-3.537010e-03, 223,-4.933220e-04, 224,2.035181e-03,
+ 225,8.264298e-03, 226,-6.368051e-04, 227,-9.209748e-03, 228,5.104044e-03, 229,8.289900e-04, 230,9.834593e-03, 231,-9.535855e-03, 232,-8.513549e-03,
+ 233,-1.720410e-04, 234,-6.789172e-03, 235,-6.174429e-03, 236,-3.404447e-03, 237,-4.974504e-03, 238,-2.883460e-03, 239,4.913736e-03, 240,8.955754e-04,
+ 241,-4.887391e-03, 242,8.209420e-03, 243,9.617714e-03, 244,-1.108153e-03, 245,-6.634963e-03, 246,-7.228676e-03, 247,2.869704e-03, 248,-5.001598e-03,
+ 249,7.993985e-03, 250,8.116800e-03, 251,-7.536948e-03, 252,4.210168e-03, 253,-1.000000e-02, 254,1.000000e-02, 255,-1.000000e-02, 256,-1.000000e-02,
+ 257,1.000000e-02, 258,-1.000000e-02, 259,-1.000000e-02)
.param K46=table(run, 1,5.000000e-03, 2,5.000000e-03, 3,-2.245247e-03, 4,8.779303e-03, 5,-6.903235e-03, 6,-3.451734e-03, 7,4.438779e-03, 8,-4.593574e-04,
+ 9,-7.068525e-03, 10,5.047829e-03, 11,-7.358886e-03, 12,-5.033151e-03, 13,-5.863312e-03, 14,4.778409e-03, 15,-8.796830e-03, 16,5.947622e-03,
+ 17,-1.520838e-03, 18,4.348566e-03, 19,-3.138039e-03, 20,-1.905383e-03, 21,1.063787e-03, 22,7.073668e-03, 23,9.178769e-03, 24,-2.287409e-03,
+ 25,7.858908e-03, 26,-8.051398e-03, 27,-7.890145e-04, 28,7.875618e-03, 29,-9.856846e-04, 30,-6.637828e-03, 31,2.292787e-03, 32,-2.968510e-03,
+ 33,3.319215e-03, 34,-9.307757e-03, 35,8.405634e-03, 36,-8.515850e-03, 37,-8.260386e-03, 38,3.580947e-03, 39,-5.269225e-03, 40,5.972925e-04,
+ 41,-2.336548e-03, 42,5.601315e-03, 43,-5.065864e-03, 44,-1.457898e-03, 45,-7.531846e-03, 46,4.694247e-03, 47,5.355792e-03, 48,-2.988459e-03,
+ 49,1.449979e-03, 50,-3.368319e-04, 51,2.972460e-03, 52,-2.498985e-03, 53,2.139460e-03, 54,-1.417961e-03, 55,-9.657100e-03, 56,-5.838891e-03,
+ 57,-8.753204e-03, 58,2.274385e-03, 59,4.579640e-03, 60,-5.272715e-03, 61,9.169237e-03, 62,-8.676484e-03, 63,-5.219242e-03, 64,1.548746e-05,
+ 65,-5.336411e-03, 66,8.851659e-03, 67,-3.292887e-03, 68,-4.920212e-03, 69,-5.759908e-04, 70,3.275387e-03, 71,4.004728e-03, 72,7.014043e-03,
+ 73,-1.864707e-03, 74,-9.854620e-03, 75,1.044231e-03, 76,-5.598519e-03, 77,2.128153e-03, 78,4.578700e-03, 79,3.249434e-03, 80,-1.469188e-03,
+ 81,5.277688e-03, 82,9.028235e-03, 83,6.878727e-03, 84,-4.177125e-03, 85,-6.100148e-03, 86,4.120958e-03, 87,-1.625162e-03, 88,1.429435e-03,
+ 89,-3.671822e-03, 90,-7.109922e-03, 91,6.958814e-03, 92,-9.205646e-03, 93,5.420577e-03, 94,-3.200414e-03, 95,-3.853452e-03, 96,9.275627e-03,
+ 97,-7.611844e-03, 98,-8.953869e-03, 99,8.374186e-03, 100,-3.893921e-03, 101,5.460105e-03, 102,2.533568e-04, 103,9.774609e-03, 104,1.158063e-03,
+ 105,-2.512261e-03, 106,-1.055104e-03, 107,-4.416872e-03, 108,-4.143390e-03, 109,2.657421e-03, 110,-3.399155e-03, 111,3.932527e-03, 112,3.903998e-03,
+ 113,9.522742e-03, 114,1.236955e-03, 115,-9.212796e-03, 116,9.811594e-03, 117,5.651003e-03, 118,3.991846e-03, 119,-7.180642e-03, 120,-9.934161e-03,
+ 121,1.729769e-04, 122,8.423333e-03, 123,-8.948999e-03, 124,5.093710e-03, 125,5.571264e-03, 126,4.727172e-03, 127,4.468467e-03, 128,9.607927e-03,
+ 129,1.613960e-03, 130,-4.099000e-03, 131,-1.982833e-03, 132,3.682798e-03, 133,-6.394423e-03, 134,-4.827676e-03, 135,1.885588e-03, 136,-8.032040e-03,
+ 137,-8.119877e-03, 138,-4.231552e-03, 139,5.913089e-03, 140,2.399977e-03, 141,2.982185e-03, 142,-9.440726e-03, 143,8.106362e-03, 144,2.011791e-03,
+ 145,-5.181279e-03, 146,-9.458334e-04, 147,-5.878765e-03, 148,-4.806660e-04, 149,2.659217e-03, 150,4.190240e-03, 151,-9.530847e-04, 152,-3.308779e-03,
+ 153,-9.169917e-03, 154,4.013342e-03, 155,-7.702005e-03, 156,-9.522932e-03, 157,8.300548e-03, 158,-8.170758e-03, 159,-8.858875e-03, 160,-2.525439e-03,
+ 161,9.077541e-03, 162,9.490219e-03, 163,-3.900449e-03, 164,-8.492612e-03, 165,8.414886e-04, 166,5.817742e-03, 167,-8.167593e-03, 168,-1.786679e-03,
+ 169,8.695607e-03, 170,-3.280475e-03, 171,-5.880838e-03, 172,-7.381234e-03, 173,-2.483203e-03, 174,4.203054e-03, 175,-4.816094e-03, 176,9.148566e-03,
+ 177,6.178458e-03, 178,4.131495e-03, 179,-6.835475e-03, 180,3.208937e-04, 181,-5.708877e-03, 182,-8.787302e-03, 183,-9.623537e-03, 184,-2.512670e-03,
+ 185,-5.390415e-03, 186,9.307364e-03, 187,6.374060e-03, 188,-7.890402e-03, 189,8.649231e-03, 190,-5.932586e-03, 191,9.838283e-03, 192,-3.435110e-03,
+ 193,1.191682e-03, 194,-9.531945e-03, 195,-7.096524e-04, 196,-8.931617e-03, 197,-3.042629e-03, 198,-4.301040e-03, 199,5.018682e-03, 200,-9.435572e-03,
+ 201,8.506063e-03, 202,7.919892e-03, 203,-4.910694e-03, 204,1.447885e-03, 205,-3.632156e-03, 206,4.276552e-03, 207,-2.272049e-03, 208,-7.744302e-03,
+ 209,-4.015666e-03, 210,-3.563715e-03, 211,-7.148106e-03, 212,9.707314e-03, 213,6.909369e-03, 214,-1.562941e-03, 215,-5.396179e-03, 216,-5.701642e-03,
+ 217,-3.978788e-04, 218,4.778900e-04, 219,7.564205e-03, 220,-7.653046e-03, 221,2.508087e-03, 222,4.113057e-03, 223,-7.767537e-04, 224,-6.104088e-03,
+ 225,-8.337761e-03, 226,4.818898e-03, 227,9.976381e-04, 228,7.461190e-03, 229,7.468452e-03, 230,6.037868e-03, 231,4.469355e-03, 232,-5.373479e-03,
+ 233,2.968300e-03, 234,-7.048410e-03, 235,-1.142386e-04, 236,-3.819013e-03, 237,4.966418e-03, 238,6.732909e-03, 239,1.718938e-03, 240,-5.223506e-03,
+ 241,-7.496300e-03, 242,-5.642991e-03, 243,-1.562188e-03, 244,9.492299e-03, 245,-6.553573e-03, 246,-8.793213e-04, 247,-7.565600e-03, 248,4.506756e-03,
+ 249,-6.286706e-03, 250,2.323469e-03, 251,6.204167e-03, 252,6.668249e-03, 253,-1.000000e-02, 254,1.000000e-02, 255,-1.000000e-02, 256,-1.000000e-02,
+ 257,1.000000e-02, 258,-1.000000e-02, 259,-1.000000e-02)
.param K26=table(run, 1,1.000000e-03, 2,1.000000e-03, 3,-1.125399e-03, 4,-6.256421e-04, 5,-2.191809e-03, 6,-2.909710e-03, 7,1.555194e-03, 8,6.270212e-04,
+ 9,8.708168e-04, 10,-2.845127e-03, 11,2.700372e-03, 12,-2.347009e-03, 13,-1.653634e-03, 14,1.110196e-03, 15,2.041099e-05, 16,-3.642008e-04,
+ 17,4.260433e-04, 18,1.190088e-03, 19,9.723115e-04, 20,7.426832e-04, 21,-1.490030e-03, 22,2.899728e-04, 23,-7.753971e-04, 24,1.838923e-03,
+ 25,1.729406e-03, 26,2.524624e-03, 27,-8.530687e-04, 28,-2.599329e-03, 29,2.273026e-03, 30,-2.198833e-03, 31,-2.033719e-03, 32,4.991875e-04,
+ 33,1.488757e-03, 34,-2.524610e-03, 35,2.813297e-03, 36,-2.463347e-03, 37,2.516482e-03, 38,-2.139339e-03, 39,-1.318554e-03, 40,3.330643e-04,
+ 41,-2.214787e-03, 42,-2.644541e-03, 43,1.871218e-04, 44,4.859939e-04, 45,2.124521e-03, 46,1.191211e-03, 47,-9.966205e-05, 48,-1.895792e-04,
+ 49,-4.185216e-04, 50,-2.083275e-03, 51,-1.264692e-03, 52,4.953438e-04, 53,2.609774e-03, 54,6.382354e-04, 55,1.763924e-03, 56,-3.375350e-05,
+ 57,-3.241248e-05, 58,1.806797e-03, 59,-4.809984e-04, 60,-2.633557e-03, 61,-4.843326e-04, 62,-2.466081e-03, 63,8.410925e-04, 64,2.257960e-03,
+ 65,-2.478726e-03, 66,5.457061e-04, 67,-2.295528e-03, 68,1.891776e-03, 69,-2.619583e-03, 70,-1.763887e-03, 71,-9.161062e-05, 72,1.538793e-03,
+ 73,6.282058e-05, 74,2.046528e-03, 75,-2.215638e-04, 76,1.420445e-03, 77,1.638148e-03, 78,-2.406847e-03, 79,-1.799531e-03, 80,2.155833e-03,
+ 81,-2.687058e-03, 82,-7.607457e-04, 83,-2.626506e-03, 84,-1.528490e-03, 85,6.721317e-04, 86,-2.633192e-03, 87,-1.159313e-03, 88,-2.500818e-03,
+ 89,-8.973172e-04, 90,2.762151e-03, 91,-1.826571e-03, 92,-2.159028e-03, 93,-2.591747e-03, 94,-1.110060e-03, 95,2.884886e-03, 96,-2.881447e-03,
+ 97,2.689855e-03, 98,2.518892e-03, 99,-2.427278e-03, 100,2.871030e-03, 101,-8.540080e-05, 102,-5.385533e-04, 103,-1.284446e-03, 104,-1.374209e-03,
+ 105,-1.402102e-03, 106,5.944486e-04, 107,-5.800923e-04, 108,1.390229e-03, 109,-1.859511e-03, 110,-1.855503e-03, 111,2.086214e-03, 112,2.707460e-03,
+ 113,-1.196991e-03, 114,9.324522e-04, 115,2.956121e-04, 116,-2.729238e-03, 117,-1.962739e-04, 118,-2.754034e-03, 119,2.609748e-03, 120,1.405343e-03,
+ 121,-2.333238e-03, 122,2.293289e-03, 123,9.207360e-04, 124,1.641439e-03, 125,-6.440791e-04, 126,2.065231e-03, 127,8.331239e-04, 128,8.480727e-04,
+ 129,8.104586e-04, 130,-1.892333e-03, 131,1.983803e-03, 132,1.211675e-03, 133,9.368801e-04, 134,-1.525649e-03, 135,-1.554358e-03, 136,-8.935930e-04,
+ 137,2.485406e-03, 138,1.780774e-03, 139,1.891282e-03, 140,7.720745e-04, 141,2.552756e-03, 142,-1.348197e-03, 143,2.697505e-03, 144,-2.456815e-03,
+ 145,2.329983e-04, 146,7.225098e-04, 147,1.858239e-03, 148,2.455473e-03, 149,-2.479159e-03, 150,-1.667063e-03, 151,-9.232112e-04, 152,-5.859223e-05,
+ 153,1.261864e-04, 154,3.342115e-04, 155,-8.959130e-04, 156,6.661123e-04, 157,1.593275e-04, 158,1.778820e-04, 159,-1.154730e-04, 160,6.099637e-04,
+ 161,2.891491e-03, 162,1.478492e-03, 163,1.856364e-03, 164,-1.439919e-03, 165,2.725028e-03, 166,-2.168799e-03, 167,-3.583684e-04, 168,1.730070e-03,
+ 169,-2.686748e-03, 170,-1.527305e-03, 171,2.888943e-03, 172,-5.483929e-04, 173,-4.295711e-04, 174,-1.497221e-03, 175,2.260980e-03, 176,-2.709621e-03,
+ 177,1.997990e-03, 178,-3.646271e-04, 179,2.025738e-03, 180,2.918170e-03, 181,7.748067e-04, 182,-2.051869e-04, 183,1.235539e-03, 184,-1.229337e-03,
+ 185,-2.738039e-03, 186,-9.967647e-05, 187,-1.834666e-03, 188,-3.073161e-04, 189,-1.070108e-03, 190,-2.116406e-03, 191,1.380059e-03, 192,-1.937668e-03,
+ 193,1.050931e-04, 194,2.680271e-03, 195,-8.877802e-04, 196,-2.845278e-03, 197,-7.641122e-04, 198,-1.202166e-03, 199,-9.621698e-04, 200,4.604168e-04,
+ 201,-4.247538e-04, 202,-1.748347e-03, 203,-2.527614e-03, 204,9.168947e-04, 205,-2.308053e-03, 206,-2.663318e-03, 207,-2.597074e-03, 208,2.840253e-04,
+ 209,-3.927188e-04, 210,2.859542e-03, 211,2.347726e-03, 212,-2.230111e-03, 213,-7.526148e-05, 214,-9.937867e-04, 215,1.321473e-03, 216,-9.269065e-04,
+ 217,1.728916e-03, 218,-1.025838e-03, 219,2.794932e-03, 220,-2.369099e-03, 221,8.936747e-04, 222,5.186377e-04, 223,-1.096295e-03, 224,2.500649e-03,
+ 225,9.997399e-04, 226,2.599105e-03, 227,2.363315e-03, 228,-1.372931e-03, 229,2.189955e-03, 230,3.320628e-04, 231,-1.745161e-03, 232,-1.625502e-03,
+ 233,-1.162534e-03, 234,2.389412e-03, 235,5.555966e-04, 236,1.234784e-04, 237,-1.730912e-03, 238,-1.433341e-03, 239,-2.416845e-03, 240,-2.300821e-03,
+ 241,-1.780013e-05, 242,-1.097120e-03, 243,-4.976598e-05, 244,-8.509467e-04, 245,-8.590829e-04, 246,-2.516224e-03, 247,2.873837e-03, 248,1.158186e-03,
+ 249,2.124086e-04, 250,1.000587e-03, 251,1.984103e-03, 252,-2.219756e-03, 253,3.000000e-03, 254,-3.000000e-03, 255,3.000000e-03, 256,3.000000e-03,
+ 257,-3.000000e-03, 258,3.000000e-03, 259,3.000000e-03)
.param Cio=table(run, 1,2.000000e-15, 2,2.000000e-15, 3,2.098985e-15, 4,3.690541e-15, 5,3.831881e-15, 6,3.582099e-15, 7,2.779697e-15, 8,3.539089e-15,
+ 9,7.088650e-16, 10,5.559695e-16, 11,1.178958e-15, 12,4.405023e-15, 13,3.862117e-15, 14,3.924934e-15, 15,4.573577e-15, 16,9.999164e-16,
+ 17,4.950385e-15, 18,1.709714e-15, 19,8.922070e-16, 20,3.573033e-15, 21,2.074236e-15, 22,4.181046e-15, 23,3.548232e-15, 24,4.124653e-15,
+ 25,2.175127e-15, 26,3.447928e-15, 27,4.420820e-15, 28,3.165677e-15, 29,4.094165e-15, 30,2.074646e-15, 31,4.764601e-15, 32,2.171988e-15,
+ 33,2.214535e-15, 34,2.703904e-15, 35,8.141721e-16, 36,3.032484e-15, 37,3.045145e-15, 38,4.180346e-15, 39,6.536817e-16, 40,2.107933e-15,
+ 41,1.358456e-15, 42,2.281067e-15, 43,2.666958e-15, 44,2.728319e-15, 45,1.404140e-15, 46,4.929462e-15, 47,4.093114e-15, 48,1.055918e-15,
+ 49,4.840431e-15, 50,4.823822e-15, 51,9.130440e-16, 52,3.649503e-15, 53,3.012878e-15, 54,3.514787e-15, 55,3.576373e-15, 56,8.271291e-16,
+ 57,4.672847e-15, 58,3.288911e-15, 59,2.315383e-15, 60,4.730285e-15, 61,1.211137e-15, 62,5.000536e-16, 63,3.663263e-15, 64,3.818646e-15,
+ 65,4.201557e-15, 66,2.535165e-15, 67,2.589234e-15, 68,5.198985e-16, 69,2.038658e-15, 70,9.851751e-16, 71,1.407069e-15, 72,2.553200e-15,
+ 73,2.663978e-15, 74,4.981295e-15, 75,2.848050e-15, 76,5.891450e-16, 77,2.337022e-15, 78,1.645865e-15, 79,4.748312e-15, 80,1.891964e-15,
+ 81,2.658631e-15, 82,2.829482e-15, 83,2.999675e-15, 84,8.645044e-16, 85,2.846038e-15, 86,3.542193e-15, 87,3.103389e-15, 88,3.737844e-15,
+ 89,4.057239e-15, 90,5.317561e-16, 91,1.218050e-15, 92,1.748541e-15, 93,4.515598e-15, 94,9.844902e-16, 95,2.211726e-15, 96,8.651050e-16,
+ 97,3.835126e-15, 98,5.779570e-16, 99,2.469680e-15, 100,4.219415e-15, 101,1.255260e-15, 102,2.989075e-15, 103,3.057711e-15, 104,8.883704e-16,
+ 105,6.393722e-16, 106,3.583367e-15, 107,1.736074e-15, 108,4.469528e-15, 109,4.659103e-15, 110,1.284096e-15, 111,1.369957e-15, 112,1.827745e-15,
+ 113,2.268078e-15, 114,1.629211e-15, 115,4.505467e-15, 116,2.913688e-15, 117,5.235616e-16, 118,4.111963e-15, 119,9.250901e-16, 120,4.145184e-15,
+ 121,1.605728e-15, 122,3.230460e-15, 123,1.622934e-15, 124,2.417639e-15, 125,3.762408e-15, 126,3.557581e-15, 127,3.904633e-15, 128,1.381573e-15,
+ 129,7.291273e-16, 130,7.894892e-16, 131,9.722007e-16, 132,1.169985e-15, 133,4.850946e-15, 134,1.437844e-15, 135,8.118948e-16, 136,2.318722e-15,
+ 137,1.989212e-15, 138,3.358949e-15, 139,1.068612e-15, 140,4.120265e-15, 141,4.050571e-15, 142,6.887107e-16, 143,2.101333e-15, 144,2.760865e-15,
+ 145,4.163719e-15, 146,1.051826e-15, 147,5.236979e-16, 148,5.315216e-16, 149,4.465762e-15, 150,1.763722e-15, 151,2.557045e-15, 152,1.753784e-15,
+ 153,2.081344e-15, 154,7.998477e-16, 155,4.003755e-15, 156,2.774044e-15, 157,1.617517e-15, 158,4.333549e-15, 159,6.202374e-16, 160,4.768129e-15,
+ 161,3.752440e-15, 162,4.377381e-15, 163,2.802205e-15, 164,9.835306e-16, 165,4.413118e-15, 166,3.162328e-15, 167,3.489024e-15, 168,4.839768e-15,
+ 169,4.755540e-15, 170,2.662542e-15, 171,1.036411e-15, 172,2.912702e-15, 173,1.086379e-15, 174,5.616130e-16, 175,4.098455e-15, 176,1.830056e-15,
+ 177,6.923501e-16, 178,2.140292e-15, 179,4.321262e-15, 180,4.027788e-15, 181,6.801207e-16, 182,1.084730e-15, 183,4.581819e-15, 184,1.184310e-15,
+ 185,2.569186e-15, 186,2.658264e-15, 187,3.428736e-15, 188,3.013302e-15, 189,4.503533e-15, 190,3.005272e-15, 191,2.173395e-15, 192,2.196189e-15,
+ 193,2.101293e-15, 194,6.720320e-16, 195,2.191300e-15, 196,4.321558e-15, 197,3.913869e-15, 198,2.515398e-15, 199,4.832365e-15, 200,3.051736e-15,
+ 201,1.723749e-15, 202,4.020550e-15, 203,1.662059e-15, 204,1.405869e-15, 205,4.396649e-15, 206,1.318343e-15, 207,6.864541e-16, 208,5.386760e-16,
+ 209,2.082308e-15, 210,4.993765e-15, 211,4.473603e-15, 212,1.620538e-15, 213,1.731481e-15, 214,2.680654e-15, 215,4.857040e-15, 216,4.591821e-15,
+ 217,3.692941e-15, 218,2.881762e-15, 219,3.832984e-15, 220,1.113368e-15, 221,1.594188e-15, 222,1.961620e-15, 223,2.290852e-15, 224,3.235294e-15,
+ 225,4.337281e-15, 226,1.408330e-15, 227,2.186762e-15, 228,1.559134e-15, 229,6.390737e-16, 230,1.760064e-15, 231,9.776496e-16, 232,3.556914e-15,
+ 233,2.108507e-15, 234,3.789699e-15, 235,4.048500e-15, 236,1.700628e-15, 237,1.447529e-15, 238,6.868344e-16, 239,2.048561e-15, 240,1.141735e-15,
+ 241,1.033466e-15, 242,4.110222e-15, 243,2.569279e-15, 244,2.229169e-15, 245,5.053680e-16, 246,2.076825e-15, 247,8.176437e-16, 248,3.584715e-15,
+ 249,2.878245e-15, 250,3.059782e-15, 251,1.337790e-15, 252,1.361586e-15, 253,5.000000e-15, 254,5.000000e-16, 255,5.000000e-15, 256,5.000000e-15,
+ 257,5.000000e-16, 258,5.000000e-15, 259,5.000000e-15)
V_m src_m 0 AC 2
RS_m src_m in_m 50
RL_m out_m 0 50
CPC1_m in_m 0 {C1Cpad}
C1_m in_m C1x1_m {C1C}
RC1_m C1x1_m C1x2_m {C1ESR}
LEC1_m C1x2_m C1x3_m {C1ESL} Rser=0
LVC1_m C1x3_m 0 {C1Lvia} Rser=0
CPC3_m a1_m 0 {C3Cpad}
C3_m a1_m C3x1_m {C3C}
RC3_m C3x1_m C3x2_m {C3ESR}
LEC3_m C3x2_m C3x3_m {C3ESL} Rser=0
LVC3_m C3x3_m 0 {C3Lvia} Rser=0
CPC5_m a2_m 0 {C5Cpad}
C5_m a2_m C5x1_m {C5C}
RC5_m C5x1_m C5x2_m {C5ESR}
LEC5_m C5x2_m C5x3_m {C5ESL} Rser=0
LVC5_m C5x3_m 0 {C5Lvia} Rser=0
CPC7_m out_m 0 {C7Cpad}
C7_m out_m C7x1_m {C7C}
RC7_m C7x1_m C7x2_m {C7ESR}
LEC7_m C7x2_m C7x3_m {C7ESL} Rser=0
LVC7_m C7x3_m 0 {C7Lvia} Rser=0
LTaL2_m in_m L2y1_m {L2Ltr/2} Rser=0
L2_m L2y1_m L2y2_m {L2L} Rser=0
RL2_m L2y2_m L2y3_m {L2R}
CSL2_m L2y1_m L2y3_m {L2C}
LTbL2_m L2y3_m a1_m {L2Ltr/2} Rser=0
LTaL4_m a1_m L4y1_m {L4Ltr/2} Rser=0
L4_m L4y1_m L4y2_m {L4L} Rser=0
RL4_m L4y2_m L4y3_m {L4R}
CSL4_m L4y1_m L4y3_m {L4C}
LTbL4_m L4y3_m a2_m {L4Ltr/2} Rser=0
LTaL6_m a2_m L6y1_m {L6Ltr/2} Rser=0
L6_m L6y1_m L6y2_m {L6L} Rser=0
RL6_m L6y2_m L6y3_m {L6R}
CSL6_m L6y1_m L6y3_m {L6C}
LTbL6_m L6y3_m out_m {L6Ltr/2} Rser=0
K24_m L2_m L4_m {K24}
K46_m L4_m L6_m {K46}
K26_m L2_m L6_m {K26}
CIO_m in_m out_m {Cio}
.ac list 2000000 4000000 6000000 8000000 10000000 12000000 14000000 16000000 18000000 20000000 22000000 24000000
+ 26000000 28000000 30000000 32000000 34000000 36000000 38000000 40000000 42000000 44000000 46000000 48000000
+ 50000000 52000000 54000000 56000000 58000000 60000000 62000000 64000000 66000000 68000000 70000000 72000000
+ 74000000 76000000 78000000 80000000 82000000 84000000 86000000 88000000 90000000 92000000 94000000 96000000
+ 98000000 100000000 102000000 104000000 106000000 108000000 110000000 112000000 114000000 116000000 118000000 120000000
+ 122000000 124000000 126000000 128000000 130000000 132000000 134000000 136000000 138000000 140000000 142000000 144000000
+ 144250000 144500000 144750000 145000000 145250000 145500000 145750000 146000000 146250000 146500000 146750000 147000000
+ 147250000 147500000 147750000 148000000 150000000 152000000 154000000 156000000 158000000 160000000 162000000 164000000
+ 166000000 168000000 170000000 172000000 174000000 176000000 178000000 180000000 182000000 184000000 186000000 188000000
+ 190000000 192000000 194000000 196000000 198000000 200000000 202000000 204000000 206000000 208000000 210000000 212000000
+ 214000000 216000000 218000000 220000000 222000000 224000000 226000000 228000000 230000000 232000000 234000000 236000000
+ 238000000 240000000 242000000 244000000 246000000 248000000 250000000 252000000 254000000 256000000 258000000 260000000
+ 262000000 264000000 266000000 268000000 270000000 272000000 274000000 276000000 278000000 280000000 282000000 284000000
+ 286000000 288000000 288500000 289000000 289500000 290000000 290500000 291000000 291500000 292000000 292500000 293000000
+ 293500000 294000000 294500000 295000000 295500000 296000000 298000000 300000000 302000000 304000000 306000000 308000000
+ 310000000 312000000 314000000 316000000 318000000 320000000 322000000 324000000 326000000 328000000 330000000 332000000
+ 334000000 336000000 338000000 340000000 342000000 344000000 346000000 348000000 350000000 352000000 354000000 356000000
+ 358000000 360000000 362000000 364000000 366000000 368000000 370000000 372000000 374000000 376000000 378000000 380000000
+ 382000000 384000000 386000000 388000000 390000000 392000000 394000000 396000000 398000000 400000000 402000000 404000000
+ 406000000 408000000 410000000 412000000 414000000 416000000 418000000 420000000 422000000 424000000 426000000 428000000
+ 430000000 432000000 432750000 433500000 434000000 434250000 435000000 435750000 436000000 436500000 437250000 438000000
+ 438750000 439500000 440000000 440250000 441000000 441750000 442000000 442500000 443250000 444000000 446000000 448000000
+ 450000000 452000000 454000000 456000000 458000000 460000000 462000000 464000000 466000000 468000000 470000000 472000000
+ 474000000 476000000 478000000 480000000 482000000 484000000 486000000 488000000 490000000 492000000 494000000 496000000
+ 498000000 500000000 502000000 504000000 506000000 508000000 510000000 512000000 514000000 516000000 518000000 520000000
+ 522000000 524000000 526000000 528000000 530000000 532000000 534000000 536000000 538000000 540000000 542000000 544000000
+ 546000000 548000000 550000000 552000000 554000000 556000000 558000000 560000000 562000000 564000000 566000000 568000000
+ 570000000 572000000 574000000 576000000 577000000 578000000 579000000 580000000 581000000 582000000 583000000 584000000
+ 585000000 586000000 587000000 588000000 589000000 590000000 591000000 592000000 594000000 596000000 598000000 600000000
+ 602000000 604000000 606000000 608000000 610000000 612000000 614000000 616000000 618000000 620000000 622000000 624000000
+ 626000000 628000000 630000000 632000000 634000000 636000000 638000000 640000000 642000000 644000000 646000000 648000000
+ 650000000 652000000 654000000 656000000 658000000 660000000 662000000 664000000 666000000 668000000 670000000 672000000
+ 674000000 676000000 678000000 680000000 682000000 684000000 686000000 688000000 690000000 692000000 694000000 696000000
+ 698000000 700000000 702000000 704000000 706000000 708000000 710000000 712000000 714000000 716000000 718000000 720000000
+ 721250000 722000000 722500000 723750000 724000000 725000000 726000000 726250000 727500000 728000000 728750000 730000000
+ 731250000 732000000 732500000 733750000 734000000 735000000 736000000 736250000 737500000 738000000 738750000 740000000
+ 742000000 744000000 746000000 748000000 750000000 752000000 754000000 756000000 758000000 760000000 762000000 764000000
+ 766000000 768000000 770000000 772000000 774000000 776000000 778000000 780000000 782000000 784000000 786000000 788000000
+ 790000000 792000000 794000000 796000000 798000000 800000000 802000000 804000000 806000000 808000000 810000000 812000000
+ 814000000 816000000 818000000 820000000 822000000 824000000 826000000 828000000 830000000 832000000 834000000 836000000
+ 838000000 840000000 842000000 844000000 846000000 848000000 850000000 852000000 854000000 856000000 858000000 860000000
+ 862000000 864000000 865500000 866000000 867000000 868000000 868500000 870000000 871500000 872000000 873000000 874000000
+ 874500000 876000000 877500000 878000000 879000000 880000000 880500000 882000000 883500000 884000000 885000000 886000000
+ 886500000 888000000 890000000 892000000 894000000 896000000 898000000 900000000 902000000 904000000 906000000 908000000
+ 910000000 912000000 914000000 916000000 918000000 920000000 922000000 924000000 926000000 928000000 930000000 932000000
+ 934000000 936000000 938000000 940000000 942000000 944000000 946000000 948000000 950000000 952000000 954000000 956000000
+ 958000000 960000000 962000000 964000000 966000000 968000000 970000000 972000000 974000000 976000000 978000000 980000000
+ 982000000 984000000 986000000 988000000 990000000 992000000 994000000 996000000 998000000 1000000000 1002000000 1004000000
+ 1006000000 1008000000 1009750000 1010000000 1011500000 1012000000 1013250000 1014000000 1015000000 1016000000 1016750000 1018000000
+ 1018500000 1020000000 1020250000 1022000000 1023750000 1024000000 1025500000 1026000000 1027250000 1028000000 1029000000 1030000000
+ 1030750000 1032000000 1032500000 1034000000 1034250000 1036000000 1038000000 1040000000 1042000000 1044000000 1046000000 1048000000
+ 1050000000 1052000000 1054000000 1056000000 1058000000 1060000000 1062000000 1064000000 1066000000 1068000000 1070000000 1072000000
+ 1074000000 1076000000 1078000000 1080000000 1082000000 1084000000 1086000000 1088000000 1090000000 1092000000 1094000000 1096000000
+ 1098000000 1100000000 1102000000 1104000000 1106000000 1108000000 1110000000 1112000000 1114000000 1116000000 1118000000 1120000000
+ 1122000000 1124000000 1126000000 1128000000 1130000000 1132000000 1134000000 1136000000 1138000000 1140000000 1142000000 1144000000
+ 1146000000 1148000000 1150000000 1152000000 1154000000 1156000000 1158000000 1160000000 1162000000 1164000000 1166000000 1168000000
+ 1170000000 1172000000 1174000000 1176000000 1178000000 1180000000 1182000000 1184000000 1186000000 1188000000 1190000000 1192000000
+ 1194000000 1196000000 1198000000 1200000000 1202000000 1204000000 1206000000 1208000000 1210000000 1212000000 1214000000 1216000000
+ 1218000000 1220000000 1222000000 1224000000 1226000000 1228000000 1230000000 1232000000 1234000000 1236000000 1238000000 1240000000
+ 1242000000 1244000000 1246000000 1248000000 1250000000 1252000000 1254000000 1256000000 1258000000 1260000000 1262000000 1264000000
+ 1266000000 1268000000 1270000000 1272000000 1274000000 1276000000 1278000000 1280000000 1282000000 1284000000 1286000000 1288000000
+ 1290000000 1292000000 1294000000 1296000000 1298000000 1298250000 1300000000 1300500000 1302000000 1302750000 1304000000 1305000000
+ 1306000000 1307250000 1308000000 1309500000 1310000000 1311750000 1312000000 1314000000 1316000000 1316250000 1318000000 1318500000
+ 1320000000 1320750000 1322000000 1323000000 1324000000 1325250000 1326000000 1327500000 1328000000 1329750000 1330000000 1332000000
+ 1334000000 1336000000 1338000000 1340000000 1342000000 1344000000 1346000000 1348000000 1350000000 1352000000 1354000000 1356000000
+ 1358000000 1360000000 1362000000 1364000000 1366000000 1368000000 1370000000 1372000000 1374000000 1376000000 1378000000 1380000000
+ 1382000000 1384000000 1386000000 1388000000 1390000000 1392000000 1394000000 1396000000 1398000000 1400000000 1402000000 1404000000
+ 1406000000 1408000000 1410000000 1412000000 1414000000 1416000000 1418000000 1420000000 1422000000 1424000000 1426000000 1428000000
+ 1430000000 1432000000 1434000000 1436000000 1438000000 1440000000 1442000000 1442500000 1444000000 1445000000 1446000000 1447500000
+ 1448000000 1450000000 1452000000 1452500000 1454000000 1455000000 1456000000 1457500000 1458000000 1460000000 1462000000 1462500000
+ 1464000000 1465000000 1466000000 1467500000 1468000000 1470000000 1472000000 1472500000 1474000000 1475000000 1476000000 1477500000
+ 1478000000 1480000000 1482000000 1484000000 1486000000 1488000000 1490000000 1492000000 1494000000 1496000000 1498000000 1500000000
+ 1502000000 1504000000 1506000000 1508000000 1510000000 1512000000 1514000000 1516000000 1518000000 1520000000 1522000000 1524000000
+ 1526000000 1528000000 1530000000 1532000000 1534000000 1536000000 1538000000 1540000000 1542000000 1544000000 1546000000 1548000000
+ 1550000000 1552000000 1554000000 1556000000 1558000000 1560000000 1562000000 1564000000 1566000000 1568000000 1570000000 1572000000
+ 1574000000 1576000000 1578000000 1580000000 1582000000 1584000000 1586000000 1588000000 1590000000 1592000000 1594000000 1596000000
+ 1598000000 1600000000
.save V(out_m) V(in_m)
.meas AC s21_146 FIND V(out_m) AT 146000000
.meas AC s21_148 FIND V(out_m) AT 148000000
.meas AC s21_288 FIND V(out_m) AT 288000000
.meas AC s21_432 FIND V(out_m) AT 432000000
.meas AC echo_L4 PARAM L4L
.end
