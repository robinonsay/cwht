* cwht TS-012 harmonic LPF, run r7 Monte Carlo: 24 AWG air coils aligned (+/-3 %), retuned 18/33 pF (2026-09-28); generated by run_lpf.py
* run 1 = all L and C at -tol, run 2 = all at +tol (nominal parasitics), runs 3..252 uniform random,
* numpy default_rng seed 21007; values also in mc_values.csv. S21 = V(out_m).
.step param run 1 252 1
.param C1C=table(run, 1,1.710000e-11, 2,1.890000e-11, 3,1.769048e-11, 4,1.833963e-11, 5,1.743654e-11, 6,1.854918e-11, 7,1.756107e-11, 8,1.768486e-11,
+ 9,1.820831e-11, 10,1.830796e-11, 11,1.858064e-11, 12,1.775723e-11, 13,1.788492e-11, 14,1.873116e-11, 15,1.739612e-11, 16,1.801049e-11,
+ 17,1.887867e-11, 18,1.865509e-11, 19,1.782836e-11, 20,1.772600e-11, 21,1.773535e-11, 22,1.722597e-11, 23,1.732889e-11, 24,1.777585e-11,
+ 25,1.818620e-11, 26,1.801836e-11, 27,1.781730e-11, 28,1.778101e-11, 29,1.821133e-11, 30,1.839132e-11, 31,1.881556e-11, 32,1.862666e-11,
+ 33,1.849258e-11, 34,1.781497e-11, 35,1.739419e-11, 36,1.744263e-11, 37,1.868879e-11, 38,1.806473e-11, 39,1.888232e-11, 40,1.875028e-11,
+ 41,1.815857e-11, 42,1.855276e-11, 43,1.720869e-11, 44,1.800028e-11, 45,1.745243e-11, 46,1.797652e-11, 47,1.825652e-11, 48,1.757187e-11,
+ 49,1.828285e-11, 50,1.873298e-11, 51,1.803000e-11, 52,1.728634e-11, 53,1.830774e-11, 54,1.765097e-11, 55,1.723286e-11, 56,1.733174e-11,
+ 57,1.811744e-11, 58,1.743726e-11, 59,1.829917e-11, 60,1.768573e-11, 61,1.842878e-11, 62,1.775119e-11, 63,1.776756e-11, 64,1.876021e-11,
+ 65,1.733868e-11, 66,1.862729e-11, 67,1.847969e-11, 68,1.802518e-11, 69,1.848126e-11, 70,1.714759e-11, 71,1.858866e-11, 72,1.886204e-11,
+ 73,1.860134e-11, 74,1.743582e-11, 75,1.872405e-11, 76,1.869487e-11, 77,1.723988e-11, 78,1.808454e-11, 79,1.794899e-11, 80,1.875858e-11,
+ 81,1.726525e-11, 82,1.738550e-11, 83,1.826127e-11, 84,1.862946e-11, 85,1.782096e-11, 86,1.767821e-11, 87,1.799849e-11, 88,1.754126e-11,
+ 89,1.860865e-11, 90,1.772896e-11, 91,1.844023e-11, 92,1.737345e-11, 93,1.854135e-11, 94,1.737121e-11, 95,1.795387e-11, 96,1.747307e-11,
+ 97,1.820063e-11, 98,1.824884e-11, 99,1.786227e-11, 100,1.744799e-11, 101,1.792245e-11, 102,1.783022e-11, 103,1.881672e-11, 104,1.710916e-11,
+ 105,1.797937e-11, 106,1.730067e-11, 107,1.867432e-11, 108,1.720762e-11, 109,1.843789e-11, 110,1.760773e-11, 111,1.810263e-11, 112,1.776070e-11,
+ 113,1.876950e-11, 114,1.777050e-11, 115,1.791701e-11, 116,1.875498e-11, 117,1.801638e-11, 118,1.800505e-11, 119,1.777744e-11, 120,1.791414e-11,
+ 121,1.883613e-11, 122,1.808084e-11, 123,1.861298e-11, 124,1.791540e-11, 125,1.855517e-11, 126,1.774960e-11, 127,1.750866e-11, 128,1.720040e-11,
+ 129,1.738624e-11, 130,1.846131e-11, 131,1.834477e-11, 132,1.799547e-11, 133,1.823369e-11, 134,1.851007e-11, 135,1.786025e-11, 136,1.825714e-11,
+ 137,1.822435e-11, 138,1.715582e-11, 139,1.776107e-11, 140,1.802660e-11, 141,1.793744e-11, 142,1.844685e-11, 143,1.839479e-11, 144,1.710378e-11,
+ 145,1.724242e-11, 146,1.824228e-11, 147,1.825581e-11, 148,1.715309e-11, 149,1.776678e-11, 150,1.749276e-11, 151,1.839322e-11, 152,1.849612e-11,
+ 153,1.717940e-11, 154,1.880136e-11, 155,1.793563e-11, 156,1.738471e-11, 157,1.745589e-11, 158,1.856274e-11, 159,1.760152e-11, 160,1.790671e-11,
+ 161,1.813866e-11, 162,1.873449e-11, 163,1.831271e-11, 164,1.804565e-11, 165,1.750038e-11, 166,1.755648e-11, 167,1.746685e-11, 168,1.711772e-11,
+ 169,1.733486e-11, 170,1.834038e-11, 171,1.831986e-11, 172,1.770829e-11, 173,1.846451e-11, 174,1.870491e-11, 175,1.773869e-11, 176,1.884892e-11,
+ 177,1.868789e-11, 178,1.768271e-11, 179,1.875425e-11, 180,1.876190e-11, 181,1.745162e-11, 182,1.793375e-11, 183,1.874760e-11, 184,1.822018e-11,
+ 185,1.813345e-11, 186,1.834157e-11, 187,1.785483e-11, 188,1.759023e-11, 189,1.779665e-11, 190,1.735162e-11, 191,1.825335e-11, 192,1.855311e-11,
+ 193,1.859340e-11, 194,1.775522e-11, 195,1.812342e-11, 196,1.841603e-11, 197,1.862166e-11, 198,1.817975e-11, 199,1.822215e-11, 200,1.741844e-11,
+ 201,1.803606e-11, 202,1.847338e-11, 203,1.808551e-11, 204,1.787943e-11, 205,1.825693e-11, 206,1.874433e-11, 207,1.859512e-11, 208,1.781480e-11,
+ 209,1.874294e-11, 210,1.761985e-11, 211,1.826503e-11, 212,1.749982e-11, 213,1.768695e-11, 214,1.754956e-11, 215,1.876321e-11, 216,1.803059e-11,
+ 217,1.870045e-11, 218,1.724052e-11, 219,1.813650e-11, 220,1.807917e-11, 221,1.775757e-11, 222,1.844610e-11, 223,1.731255e-11, 224,1.743366e-11,
+ 225,1.771691e-11, 226,1.796837e-11, 227,1.825578e-11, 228,1.768349e-11, 229,1.782855e-11, 230,1.747654e-11, 231,1.719797e-11, 232,1.796827e-11,
+ 233,1.787775e-11, 234,1.844199e-11, 235,1.855299e-11, 236,1.762185e-11, 237,1.807752e-11, 238,1.848041e-11, 239,1.739044e-11, 240,1.742604e-11,
+ 241,1.860121e-11, 242,1.868286e-11, 243,1.825107e-11, 244,1.757354e-11, 245,1.868139e-11, 246,1.732794e-11, 247,1.870105e-11, 248,1.712167e-11,
+ 249,1.833300e-11, 250,1.771646e-11, 251,1.882623e-11, 252,1.834340e-11)
.param C1ESR=table(run, 1,2.000000e-01, 2,2.000000e-01, 3,3.737559e-01, 4,3.976004e-01, 5,2.697643e-01, 6,2.700031e-01, 7,1.937316e-01, 8,3.019999e-01,
+ 9,3.671551e-01, 10,2.837265e-01, 11,1.709626e-01, 12,1.872523e-01, 13,1.182341e-01, 14,2.078661e-01, 15,3.183054e-01, 16,3.613999e-01,
+ 17,2.366323e-01, 18,2.272314e-01, 19,3.662962e-01, 20,1.165790e-01, 21,1.838050e-01, 22,2.549269e-01, 23,1.733719e-01, 24,3.359319e-01,
+ 25,1.424161e-01, 26,3.254680e-01, 27,1.606153e-01, 28,2.942245e-01, 29,3.773457e-01, 30,1.604726e-01, 31,3.965703e-01, 32,3.325677e-01,
+ 33,2.585039e-01, 34,2.424202e-01, 35,2.888690e-01, 36,3.472207e-01, 37,3.390814e-01, 38,2.580269e-01, 39,1.517867e-01, 40,2.590801e-01,
+ 41,2.148261e-01, 42,3.050198e-01, 43,1.681879e-01, 44,1.119429e-01, 45,1.308456e-01, 46,1.891357e-01, 47,2.797427e-01, 48,3.347884e-01,
+ 49,3.866419e-01, 50,1.674758e-01, 51,3.703186e-01, 52,3.663722e-01, 53,3.571734e-01, 54,1.585231e-01, 55,3.985295e-01, 56,1.524969e-01,
+ 57,1.116051e-01, 58,3.884401e-01, 59,3.510519e-01, 60,3.717876e-01, 61,1.363461e-01, 62,1.765520e-01, 63,3.360066e-01, 64,2.821873e-01,
+ 65,1.080056e-01, 66,2.959099e-01, 67,3.713396e-01, 68,1.790477e-01, 69,3.796284e-01, 70,2.722828e-01, 71,1.488905e-01, 72,3.083037e-01,
+ 73,2.632248e-01, 74,3.772729e-01, 75,3.036873e-01, 76,3.216306e-01, 77,2.016026e-01, 78,1.741342e-01, 79,2.406902e-01, 80,3.299593e-01,
+ 81,3.528618e-01, 82,3.410339e-01, 83,3.595337e-01, 84,3.945195e-01, 85,1.773745e-01, 86,1.580139e-01, 87,1.223946e-01, 88,2.609892e-01,
+ 89,3.118997e-01, 90,2.343087e-01, 91,1.484023e-01, 92,2.015727e-01, 93,1.381293e-01, 94,2.143793e-01, 95,3.579748e-01, 96,1.363756e-01,
+ 97,3.866344e-01, 98,3.457562e-01, 99,2.487586e-01, 100,3.193446e-01, 101,1.656993e-01, 102,3.626698e-01, 103,3.048795e-01, 104,2.387167e-01,
+ 105,3.308935e-01, 106,1.823381e-01, 107,2.823865e-01, 108,1.018574e-01, 109,1.265677e-01, 110,2.715748e-01, 111,1.982117e-01, 112,1.008434e-01,
+ 113,3.786110e-01, 114,1.249108e-01, 115,3.478706e-01, 116,1.917864e-01, 117,1.540064e-01, 118,2.439957e-01, 119,1.138059e-01, 120,3.165834e-01,
+ 121,2.846113e-01, 122,1.193781e-01, 123,3.178046e-01, 124,2.325664e-01, 125,2.275253e-01, 126,2.923355e-01, 127,3.636926e-01, 128,3.777860e-01,
+ 129,3.187453e-01, 130,1.472185e-01, 131,3.786098e-01, 132,3.041500e-01, 133,1.431533e-01, 134,2.386058e-01, 135,3.724969e-01, 136,3.860277e-01,
+ 137,2.596601e-01, 138,2.242452e-01, 139,1.152056e-01, 140,3.452574e-01, 141,3.631059e-01, 142,1.929524e-01, 143,3.059423e-01, 144,2.673464e-01,
+ 145,3.940547e-01, 146,3.713423e-01, 147,1.633007e-01, 148,2.138156e-01, 149,3.657255e-01, 150,3.840144e-01, 151,1.064943e-01, 152,3.763490e-01,
+ 153,1.829250e-01, 154,1.870874e-01, 155,3.533403e-01, 156,3.623096e-01, 157,1.756623e-01, 158,1.543091e-01, 159,2.972751e-01, 160,3.567642e-01,
+ 161,2.664474e-01, 162,3.016841e-01, 163,3.039034e-01, 164,3.088893e-01, 165,3.219480e-01, 166,3.603219e-01, 167,2.699909e-01, 168,2.453992e-01,
+ 169,1.974298e-01, 170,3.698785e-01, 171,3.976811e-01, 172,1.696017e-01, 173,1.858555e-01, 174,1.067415e-01, 175,1.219857e-01, 176,1.816466e-01,
+ 177,2.323331e-01, 178,1.805396e-01, 179,2.713357e-01, 180,1.797556e-01, 181,1.234376e-01, 182,2.985904e-01, 183,1.963686e-01, 184,2.964966e-01,
+ 185,1.608725e-01, 186,2.627919e-01, 187,2.556751e-01, 188,3.054273e-01, 189,1.677088e-01, 190,2.678337e-01, 191,2.382095e-01, 192,1.645158e-01,
+ 193,1.896848e-01, 194,3.454419e-01, 195,2.980249e-01, 196,2.817127e-01, 197,1.031510e-01, 198,2.279977e-01, 199,2.972174e-01, 200,2.257959e-01,
+ 201,1.754586e-01, 202,1.898029e-01, 203,1.239402e-01, 204,2.834343e-01, 205,2.320787e-01, 206,1.986157e-01, 207,1.129947e-01, 208,2.204412e-01,
+ 209,3.226442e-01, 210,3.170822e-01, 211,2.021337e-01, 212,1.609005e-01, 213,1.813598e-01, 214,2.077651e-01, 215,3.408886e-01, 216,2.238925e-01,
+ 217,1.692983e-01, 218,3.736037e-01, 219,1.236087e-01, 220,2.636438e-01, 221,3.355722e-01, 222,2.289593e-01, 223,3.980642e-01, 224,2.798201e-01,
+ 225,2.217516e-01, 226,2.360880e-01, 227,1.470338e-01, 228,3.747353e-01, 229,1.853407e-01, 230,2.775830e-01, 231,3.276802e-01, 232,1.632647e-01,
+ 233,2.449030e-01, 234,2.872190e-01, 235,1.370477e-01, 236,2.640539e-01, 237,1.970336e-01, 238,3.994896e-01, 239,3.490957e-01, 240,1.564526e-01,
+ 241,2.031420e-01, 242,3.273159e-01, 243,1.557592e-01, 244,1.435208e-01, 245,3.674069e-01, 246,1.083755e-01, 247,3.252632e-01, 248,1.363033e-01,
+ 249,1.884614e-01, 250,2.887405e-01, 251,3.282278e-01, 252,1.243208e-01)
.param C1ESL=table(run, 1,1.000000e-09, 2,1.000000e-09, 3,6.192918e-10, 4,1.197018e-09, 5,9.399189e-10, 6,1.142530e-09, 7,1.184693e-09, 8,9.057601e-10,
+ 9,7.852129e-10, 10,7.964157e-10, 11,1.002296e-09, 12,6.463756e-10, 13,9.251083e-10, 14,1.165836e-09, 15,9.233978e-10, 16,9.721660e-10,
+ 17,9.525509e-10, 18,1.184889e-09, 19,6.489794e-10, 20,9.160539e-10, 21,8.910400e-10, 22,1.102598e-09, 23,8.794045e-10, 24,6.181540e-10,
+ 25,8.093041e-10, 26,8.367696e-10, 27,1.151050e-09, 28,1.045577e-09, 29,6.340238e-10, 30,1.151759e-09, 31,1.115899e-09, 32,1.076612e-09,
+ 33,9.260763e-10, 34,9.883610e-10, 35,6.084891e-10, 36,1.107761e-09, 37,1.010089e-09, 38,1.162266e-09, 39,6.149784e-10, 40,7.813712e-10,
+ 41,7.937731e-10, 42,6.852719e-10, 43,8.888438e-10, 44,7.749331e-10, 45,7.203191e-10, 46,8.772931e-10, 47,8.313786e-10, 48,7.295142e-10,
+ 49,9.509158e-10, 50,6.581931e-10, 51,8.116521e-10, 52,1.054597e-09, 53,1.113251e-09, 54,1.050422e-09, 55,1.121111e-09, 56,9.288554e-10,
+ 57,1.018515e-09, 58,1.016487e-09, 59,1.049593e-09, 60,1.192688e-09, 61,6.040156e-10, 62,1.133308e-09, 63,1.147658e-09, 64,1.173845e-09,
+ 65,8.290071e-10, 66,9.603538e-10, 67,6.380875e-10, 68,6.560773e-10, 69,1.137634e-09, 70,6.243019e-10, 71,1.122432e-09, 72,7.301537e-10,
+ 73,1.180552e-09, 74,7.762830e-10, 75,1.091546e-09, 76,7.618887e-10, 77,7.130485e-10, 78,8.830697e-10, 79,9.040272e-10, 80,9.987658e-10,
+ 81,1.128480e-09, 82,1.184056e-09, 83,1.188922e-09, 84,1.185709e-09, 85,8.841251e-10, 86,6.896332e-10, 87,8.744094e-10, 88,8.024136e-10,
+ 89,1.128198e-09, 90,8.528206e-10, 91,7.868888e-10, 92,8.104470e-10, 93,8.418886e-10, 94,6.669414e-10, 95,8.612336e-10, 96,1.073962e-09,
+ 97,1.194819e-09, 98,1.024934e-09, 99,1.082730e-09, 100,1.071422e-09, 101,7.187121e-10, 102,6.880366e-10, 103,1.189500e-09, 104,6.584498e-10,
+ 105,9.863414e-10, 106,9.539152e-10, 107,1.112280e-09, 108,1.044150e-09, 109,9.773746e-10, 110,1.059139e-09, 111,8.373251e-10, 112,7.733646e-10,
+ 113,9.677185e-10, 114,7.502042e-10, 115,1.055368e-09, 116,1.056608e-09, 117,1.050603e-09, 118,9.817350e-10, 119,6.397165e-10, 120,1.039093e-09,
+ 121,8.431780e-10, 122,9.761140e-10, 123,1.150644e-09, 124,7.288448e-10, 125,1.053216e-09, 126,1.042001e-09, 127,1.164278e-09, 128,8.018542e-10,
+ 129,6.236216e-10, 130,1.107830e-09, 131,6.093025e-10, 132,1.008584e-09, 133,9.735268e-10, 134,7.143691e-10, 135,1.118772e-09, 136,8.911745e-10,
+ 137,1.071264e-09, 138,8.550329e-10, 139,9.659590e-10, 140,9.725493e-10, 141,6.104960e-10, 142,6.034202e-10, 143,6.708764e-10, 144,7.947233e-10,
+ 145,1.006780e-09, 146,6.541442e-10, 147,7.241739e-10, 148,6.787661e-10, 149,9.506433e-10, 150,1.096307e-09, 151,9.873932e-10, 152,9.060330e-10,
+ 153,9.322025e-10, 154,6.017801e-10, 155,7.574115e-10, 156,8.710073e-10, 157,7.861468e-10, 158,8.882942e-10, 159,6.068057e-10, 160,9.286072e-10,
+ 161,9.075601e-10, 162,8.413293e-10, 163,8.246738e-10, 164,7.231504e-10, 165,9.161516e-10, 166,1.144985e-09, 167,6.719030e-10, 168,9.901833e-10,
+ 169,7.845723e-10, 170,7.895612e-10, 171,1.199766e-09, 172,6.405579e-10, 173,9.151753e-10, 174,1.088239e-09, 175,1.050685e-09, 176,7.363421e-10,
+ 177,1.168107e-09, 178,1.010841e-09, 179,1.164031e-09, 180,1.013534e-09, 181,7.917922e-10, 182,6.265663e-10, 183,1.038056e-09, 184,7.467199e-10,
+ 185,1.036011e-09, 186,9.950713e-10, 187,8.430482e-10, 188,9.696494e-10, 189,6.268222e-10, 190,6.407484e-10, 191,6.601132e-10, 192,8.453718e-10,
+ 193,1.121334e-09, 194,1.019885e-09, 195,7.590866e-10, 196,7.967118e-10, 197,1.026583e-09, 198,9.061693e-10, 199,1.048070e-09, 200,8.078724e-10,
+ 201,7.441250e-10, 202,1.089856e-09, 203,6.245967e-10, 204,9.133186e-10, 205,1.010345e-09, 206,1.084126e-09, 207,8.138629e-10, 208,9.519246e-10,
+ 209,1.179697e-09, 210,6.942410e-10, 211,7.547424e-10, 212,1.111141e-09, 213,8.531175e-10, 214,8.401026e-10, 215,8.958616e-10, 216,1.181033e-09,
+ 217,8.838463e-10, 218,1.033386e-09, 219,6.577863e-10, 220,8.627408e-10, 221,1.131475e-09, 222,7.173179e-10, 223,8.238916e-10, 224,1.027642e-09,
+ 225,1.033379e-09, 226,1.127903e-09, 227,7.712671e-10, 228,8.885544e-10, 229,1.021512e-09, 230,1.176831e-09, 231,1.143510e-09, 232,9.502253e-10,
+ 233,8.106734e-10, 234,1.105631e-09, 235,9.165089e-10, 236,9.054877e-10, 237,1.010210e-09, 238,1.006953e-09, 239,7.471917e-10, 240,1.006156e-09,
+ 241,1.048581e-09, 242,1.082071e-09, 243,6.365213e-10, 244,9.740874e-10, 245,1.097872e-09, 246,9.871707e-10, 247,6.016209e-10, 248,1.132464e-09,
+ 249,8.738969e-10, 250,8.868155e-10, 251,8.589281e-10, 252,1.104823e-09)
.param C1Lvia=table(run, 1,8.496433e-10, 2,8.496433e-10, 3,4.877221e-10, 4,4.584042e-10, 5,1.067803e-09, 6,7.104697e-10, 7,7.425402e-10, 8,9.676891e-10,
+ 9,1.042002e-09, 10,8.977843e-10, 11,7.545945e-10, 12,5.098410e-10, 13,1.221495e-09, 14,6.360890e-10, 15,6.323292e-10, 16,7.040584e-10,
+ 17,1.104184e-09, 18,5.927063e-10, 19,2.789824e-10, 20,9.031020e-10, 21,4.262973e-10, 22,7.756426e-10, 23,8.362854e-10, 24,1.251495e-09,
+ 25,7.907980e-10, 26,1.140242e-09, 27,1.294484e-09, 28,7.382911e-10, 29,4.038925e-10, 30,6.498889e-10, 31,2.722908e-10, 32,4.055016e-10,
+ 33,9.684079e-10, 34,7.652241e-10, 35,2.830579e-10, 36,6.152600e-10, 37,1.216323e-09, 38,5.083964e-10, 39,3.730255e-10, 40,1.142787e-09,
+ 41,2.781032e-10, 42,1.087841e-09, 43,6.856398e-10, 44,6.689598e-10, 45,9.279402e-10, 46,7.935649e-10, 47,8.379695e-10, 48,4.881668e-10,
+ 49,8.468847e-10, 50,1.169197e-09, 51,7.551073e-10, 52,9.010380e-10, 53,1.211598e-09, 54,4.105478e-10, 55,9.162460e-10, 56,4.997890e-10,
+ 57,4.947410e-10, 58,6.883887e-10, 59,6.180049e-10, 60,9.274172e-10, 61,7.844054e-10, 62,7.619913e-10, 63,8.965659e-10, 64,6.786057e-10,
+ 65,1.241396e-09, 66,1.250705e-09, 67,7.670595e-10, 68,7.463941e-10, 69,6.238509e-10, 70,1.193255e-09, 71,9.868245e-10, 72,5.657465e-10,
+ 73,8.968432e-10, 74,9.393819e-10, 75,3.155562e-10, 76,6.039783e-10, 77,7.376977e-10, 78,6.355917e-10, 79,9.889711e-10, 80,7.560491e-10,
+ 81,5.534912e-10, 82,1.013730e-09, 83,7.954286e-10, 84,4.195202e-10, 85,1.056981e-09, 86,1.119332e-09, 87,8.480922e-10, 88,8.330245e-10,
+ 89,2.757329e-10, 90,1.242140e-09, 91,1.147735e-09, 92,6.221288e-10, 93,1.125872e-09, 94,9.175063e-10, 95,6.844031e-10, 96,4.736365e-10,
+ 97,3.608663e-10, 98,1.194737e-09, 99,1.164011e-09, 100,1.012583e-09, 101,4.780407e-10, 102,9.511859e-10, 103,5.320420e-10, 104,1.000192e-09,
+ 105,1.016989e-09, 106,5.226933e-10, 107,9.073787e-10, 108,4.750178e-10, 109,1.220486e-09, 110,9.385600e-10, 111,3.031273e-10, 112,3.902438e-10,
+ 113,6.105774e-10, 114,9.738991e-10, 115,4.982254e-10, 116,3.932995e-10, 117,9.292646e-10, 118,1.295208e-09, 119,9.098602e-10, 120,5.021953e-10,
+ 121,8.838984e-10, 122,7.808742e-10, 123,1.041711e-09, 124,7.361237e-10, 125,6.820835e-10, 126,2.990681e-10, 127,9.507723e-10, 128,7.891401e-10,
+ 129,7.969436e-10, 130,5.041356e-10, 131,1.109731e-09, 132,6.788573e-10, 133,4.243315e-10, 134,4.958489e-10, 135,1.017840e-09, 136,1.199715e-09,
+ 137,5.139612e-10, 138,1.125833e-09, 139,7.839048e-10, 140,4.124344e-10, 141,5.778111e-10, 142,5.361816e-10, 143,7.436320e-10, 144,5.496253e-10,
+ 145,6.006435e-10, 146,1.137828e-09, 147,8.249048e-10, 148,1.131061e-09, 149,5.715102e-10, 150,7.736235e-10, 151,7.855818e-10, 152,8.185648e-10,
+ 153,2.835485e-10, 154,1.024813e-09, 155,2.890353e-10, 156,8.079840e-10, 157,1.204710e-09, 158,4.033776e-10, 159,7.434206e-10, 160,2.731231e-10,
+ 161,8.744991e-10, 162,6.151329e-10, 163,7.615864e-10, 164,1.008071e-09, 165,9.978881e-10, 166,1.282706e-09, 167,5.847200e-10, 168,9.663467e-10,
+ 169,8.568224e-10, 170,9.416819e-10, 171,6.646782e-10, 172,3.568038e-10, 173,6.851084e-10, 174,6.869806e-10, 175,3.935742e-10, 176,1.257877e-09,
+ 177,1.121779e-09, 178,5.196143e-10, 179,1.022135e-09, 180,8.628411e-10, 181,6.953555e-10, 182,7.397249e-10, 183,4.889482e-10, 184,1.009161e-09,
+ 185,3.032558e-10, 186,8.060576e-10, 187,1.139334e-09, 188,9.238338e-10, 189,6.869406e-10, 190,5.121855e-10, 191,3.477548e-10, 192,1.181227e-09,
+ 193,1.205113e-09, 194,1.015216e-09, 195,4.182614e-10, 196,4.863758e-10, 197,1.152787e-09, 198,5.532469e-10, 199,1.281749e-09, 200,6.701090e-10,
+ 201,1.021104e-09, 202,7.101442e-10, 203,1.246698e-09, 204,5.748859e-10, 205,9.982160e-10, 206,9.836995e-10, 207,8.603120e-10, 208,4.547192e-10,
+ 209,3.082210e-10, 210,1.146357e-09, 211,6.961014e-10, 212,8.704460e-10, 213,9.517191e-10, 214,1.240495e-09, 215,9.768289e-10, 216,1.236368e-09,
+ 217,4.525280e-10, 218,8.349133e-10, 219,7.763376e-10, 220,4.071492e-10, 221,1.094058e-09, 222,2.946145e-10, 223,1.245779e-09, 224,3.217114e-10,
+ 225,9.074318e-10, 226,3.326206e-10, 227,3.782007e-10, 228,1.204533e-09, 229,1.292748e-09, 230,1.029970e-09, 231,9.835699e-10, 232,1.094901e-09,
+ 233,7.773429e-10, 234,7.151533e-10, 235,1.260398e-09, 236,7.606415e-10, 237,3.502359e-10, 238,1.249035e-09, 239,6.843337e-10, 240,5.655743e-10,
+ 241,4.466670e-10, 242,8.106808e-10, 243,5.316013e-10, 244,8.249068e-10, 245,8.520759e-10, 246,6.151336e-10, 247,8.699847e-10, 248,7.475685e-10,
+ 249,8.993670e-10, 250,3.597323e-10, 251,9.000540e-10, 252,2.945665e-10)
.param C1Cpad=table(run, 1,3.489749e-13, 2,3.489749e-13, 3,2.572330e-13, 4,3.253348e-13, 5,4.656951e-13, 6,4.266100e-13, 7,4.758714e-13, 8,4.631758e-13,
+ 9,2.943863e-13, 10,3.914769e-13, 11,5.263490e-13, 12,4.086039e-13, 13,3.781633e-13, 14,2.312102e-13, 15,4.048532e-13, 16,2.289995e-13,
+ 17,3.597270e-13, 18,4.085719e-13, 19,5.174663e-13, 20,5.208189e-13, 21,1.739201e-13, 22,2.618870e-13, 23,2.546330e-13, 24,3.471025e-13,
+ 25,3.014619e-13, 26,2.672160e-13, 27,4.185487e-13, 28,3.659689e-13, 29,1.707669e-13, 30,2.000956e-13, 31,1.849132e-13, 32,3.237890e-13,
+ 33,1.700604e-13, 34,2.215368e-13, 35,4.461116e-13, 36,2.975836e-13, 37,2.849381e-13, 38,5.014067e-13, 39,4.452047e-13, 40,1.889576e-13,
+ 41,2.303695e-13, 42,1.904949e-13, 43,2.197337e-13, 44,3.008313e-13, 45,3.710464e-13, 46,3.229291e-13, 47,2.817440e-13, 48,2.227550e-13,
+ 49,4.666350e-13, 50,2.099760e-13, 51,3.332585e-13, 52,4.173422e-13, 53,2.281747e-13, 54,1.817715e-13, 55,4.533178e-13, 56,3.356889e-13,
+ 57,3.748707e-13, 58,2.491861e-13, 59,2.360952e-13, 60,3.892834e-13, 61,4.068878e-13, 62,4.230041e-13, 63,3.994604e-13, 64,5.190695e-13,
+ 65,3.048174e-13, 66,4.877904e-13, 67,3.060157e-13, 68,5.102336e-13, 69,4.961373e-13, 70,2.336668e-13, 71,4.847841e-13, 72,4.014439e-13,
+ 73,2.846854e-13, 74,2.347337e-13, 75,4.036351e-13, 76,2.828645e-13, 77,4.272982e-13, 78,4.690818e-13, 79,4.009675e-13, 80,2.057360e-13,
+ 81,4.003907e-13, 82,2.421147e-13, 83,4.959909e-13, 84,3.814244e-13, 85,1.915163e-13, 86,4.118930e-13, 87,2.036280e-13, 88,2.823184e-13,
+ 89,3.827429e-13, 90,4.337149e-13, 91,4.293011e-13, 92,2.793982e-13, 93,3.533342e-13, 94,4.909000e-13, 95,2.022265e-13, 96,5.238558e-13,
+ 97,4.800232e-13, 98,3.804953e-13, 99,2.632533e-13, 100,5.269286e-13, 101,4.311107e-13, 102,2.419050e-13, 103,5.109167e-13, 104,4.987861e-13,
+ 105,4.067838e-13, 106,4.420784e-13, 107,4.267864e-13, 108,4.739490e-13, 109,4.153625e-13, 110,2.193700e-13, 111,3.743911e-13, 112,4.364418e-13,
+ 113,5.019339e-13, 114,4.206961e-13, 115,3.396652e-13, 116,3.791168e-13, 117,4.187939e-13, 118,5.086368e-13, 119,3.181515e-13, 120,2.266209e-13,
+ 121,5.197235e-13, 122,3.326773e-13, 123,1.869615e-13, 124,2.155098e-13, 125,3.134188e-13, 126,4.108258e-13, 127,4.852361e-13, 128,4.029774e-13,
+ 129,2.388782e-13, 130,4.314747e-13, 131,4.536589e-13, 132,2.961125e-13, 133,1.748910e-13, 134,3.949754e-13, 135,4.683988e-13, 136,2.292031e-13,
+ 137,2.908736e-13, 138,3.309605e-13, 139,3.608105e-13, 140,1.775986e-13, 141,3.488731e-13, 142,3.045312e-13, 143,3.131674e-13, 144,4.410790e-13,
+ 145,3.687405e-13, 146,3.538825e-13, 147,4.435328e-13, 148,2.043009e-13, 149,3.884602e-13, 150,5.021220e-13, 151,5.049198e-13, 152,4.986636e-13,
+ 153,3.874949e-13, 154,2.865172e-13, 155,5.119724e-13, 156,3.297134e-13, 157,4.800891e-13, 158,3.982819e-13, 159,4.139453e-13, 160,3.926709e-13,
+ 161,5.198347e-13, 162,4.160755e-13, 163,2.104499e-13, 164,2.157528e-13, 165,2.697290e-13, 166,4.433861e-13, 167,1.813551e-13, 168,4.071278e-13,
+ 169,4.007973e-13, 170,1.964247e-13, 171,4.910131e-13, 172,2.744615e-13, 173,3.430154e-13, 174,5.290052e-13, 175,5.190260e-13, 176,2.935486e-13,
+ 177,3.191571e-13, 178,3.762274e-13, 179,3.800028e-13, 180,2.563320e-13, 181,4.929267e-13, 182,4.201809e-13, 183,2.137153e-13, 184,3.004474e-13,
+ 185,3.143823e-13, 186,4.488518e-13, 187,3.656573e-13, 188,2.718723e-13, 189,2.233778e-13, 190,3.191738e-13, 191,3.736657e-13, 192,1.753640e-13,
+ 193,2.259828e-13, 194,2.976593e-13, 195,3.071154e-13, 196,2.663801e-13, 197,5.109204e-13, 198,2.827476e-13, 199,4.518381e-13, 200,2.363820e-13,
+ 201,2.790603e-13, 202,3.831177e-13, 203,3.400812e-13, 204,2.727361e-13, 205,3.486337e-13, 206,3.037652e-13, 207,5.062075e-13, 208,4.768148e-13,
+ 209,2.733789e-13, 210,5.295902e-13, 211,4.018662e-13, 212,2.814391e-13, 213,3.660955e-13, 214,4.666863e-13, 215,4.478961e-13, 216,4.315610e-13,
+ 217,2.454417e-13, 218,4.319100e-13, 219,3.524270e-13, 220,2.394135e-13, 221,4.203792e-13, 222,3.785367e-13, 223,2.179213e-13, 224,3.307267e-13,
+ 225,4.879907e-13, 226,2.028334e-13, 227,4.155818e-13, 228,4.896017e-13, 229,4.218362e-13, 230,5.125991e-13, 231,2.600013e-13, 232,1.865916e-13,
+ 233,3.130799e-13, 234,3.380330e-13, 235,4.772818e-13, 236,4.257299e-13, 237,5.046460e-13, 238,2.949424e-13, 239,1.799833e-13, 240,4.058407e-13,
+ 241,3.728477e-13, 242,4.683024e-13, 243,4.376350e-13, 244,3.346527e-13, 245,3.665163e-13, 246,4.644409e-13, 247,4.689044e-13, 248,4.602262e-13,
+ 249,4.297263e-13, 250,5.214652e-13, 251,3.856409e-13, 252,1.729401e-13)
.param C3C=table(run, 1,3.135000e-11, 2,3.465000e-11, 3,3.429859e-11, 4,3.347529e-11, 5,3.172603e-11, 6,3.209578e-11, 7,3.352678e-11, 8,3.334335e-11,
+ 9,3.414808e-11, 10,3.357108e-11, 11,3.258587e-11, 12,3.197909e-11, 13,3.255389e-11, 14,3.278048e-11, 15,3.233441e-11, 16,3.313623e-11,
+ 17,3.203138e-11, 18,3.285187e-11, 19,3.410519e-11, 20,3.380507e-11, 21,3.283201e-11, 22,3.332614e-11, 23,3.230795e-11, 24,3.431270e-11,
+ 25,3.263905e-11, 26,3.176881e-11, 27,3.418459e-11, 28,3.416361e-11, 29,3.439410e-11, 30,3.412218e-11, 31,3.309693e-11, 32,3.344379e-11,
+ 33,3.382813e-11, 34,3.455188e-11, 35,3.229432e-11, 36,3.172510e-11, 37,3.206261e-11, 38,3.234547e-11, 39,3.207670e-11, 40,3.435105e-11,
+ 41,3.230642e-11, 42,3.310974e-11, 43,3.166608e-11, 44,3.256733e-11, 45,3.433530e-11, 46,3.361257e-11, 47,3.410408e-11, 48,3.455752e-11,
+ 49,3.365975e-11, 50,3.449660e-11, 51,3.353577e-11, 52,3.303307e-11, 53,3.195868e-11, 54,3.188828e-11, 55,3.368943e-11, 56,3.141972e-11,
+ 57,3.166879e-11, 58,3.219707e-11, 59,3.198136e-11, 60,3.178442e-11, 61,3.372454e-11, 62,3.357636e-11, 63,3.406881e-11, 64,3.394476e-11,
+ 65,3.388077e-11, 66,3.246751e-11, 67,3.160827e-11, 68,3.354562e-11, 69,3.164903e-11, 70,3.401770e-11, 71,3.279285e-11, 72,3.392356e-11,
+ 73,3.229445e-11, 74,3.201381e-11, 75,3.174420e-11, 76,3.216046e-11, 77,3.333054e-11, 78,3.272098e-11, 79,3.293802e-11, 80,3.183526e-11,
+ 81,3.320661e-11, 82,3.146186e-11, 83,3.259877e-11, 84,3.305007e-11, 85,3.139888e-11, 86,3.334102e-11, 87,3.328273e-11, 88,3.173425e-11,
+ 89,3.348506e-11, 90,3.418670e-11, 91,3.331109e-11, 92,3.426423e-11, 93,3.294076e-11, 94,3.167922e-11, 95,3.311128e-11, 96,3.451696e-11,
+ 97,3.462268e-11, 98,3.315925e-11, 99,3.204834e-11, 100,3.438316e-11, 101,3.298851e-11, 102,3.188887e-11, 103,3.405041e-11, 104,3.323419e-11,
+ 105,3.359830e-11, 106,3.328892e-11, 107,3.241668e-11, 108,3.226229e-11, 109,3.367055e-11, 110,3.412010e-11, 111,3.271216e-11, 112,3.222475e-11,
+ 113,3.304179e-11, 114,3.229503e-11, 115,3.369968e-11, 116,3.256699e-11, 117,3.238930e-11, 118,3.136663e-11, 119,3.195473e-11, 120,3.169266e-11,
+ 121,3.336231e-11, 122,3.402357e-11, 123,3.188245e-11, 124,3.303222e-11, 125,3.421992e-11, 126,3.399301e-11, 127,3.394219e-11, 128,3.253592e-11,
+ 129,3.374164e-11, 130,3.437744e-11, 131,3.254004e-11, 132,3.341101e-11, 133,3.450702e-11, 134,3.310614e-11, 135,3.426049e-11, 136,3.406215e-11,
+ 137,3.458357e-11, 138,3.387801e-11, 139,3.377747e-11, 140,3.325606e-11, 141,3.184815e-11, 142,3.446242e-11, 143,3.177122e-11, 144,3.448776e-11,
+ 145,3.424624e-11, 146,3.207209e-11, 147,3.299649e-11, 148,3.367379e-11, 149,3.416308e-11, 150,3.241329e-11, 151,3.330996e-11, 152,3.147632e-11,
+ 153,3.275531e-11, 154,3.284970e-11, 155,3.235938e-11, 156,3.289747e-11, 157,3.280762e-11, 158,3.257348e-11, 159,3.162309e-11, 160,3.186852e-11,
+ 161,3.330945e-11, 162,3.363159e-11, 163,3.351813e-11, 164,3.335975e-11, 165,3.315818e-11, 166,3.449496e-11, 167,3.152949e-11, 168,3.396686e-11,
+ 169,3.242233e-11, 170,3.158040e-11, 171,3.172053e-11, 172,3.438548e-11, 173,3.260747e-11, 174,3.291903e-11, 175,3.431037e-11, 176,3.370201e-11,
+ 177,3.289359e-11, 178,3.147427e-11, 179,3.150210e-11, 180,3.253235e-11, 181,3.365878e-11, 182,3.197310e-11, 183,3.254232e-11, 184,3.280641e-11,
+ 185,3.282206e-11, 186,3.314814e-11, 187,3.204269e-11, 188,3.426846e-11, 189,3.332986e-11, 190,3.176327e-11, 191,3.380115e-11, 192,3.155385e-11,
+ 193,3.295630e-11, 194,3.176969e-11, 195,3.403477e-11, 196,3.324040e-11, 197,3.179895e-11, 198,3.358783e-11, 199,3.409369e-11, 200,3.464967e-11,
+ 201,3.290628e-11, 202,3.360529e-11, 203,3.402005e-11, 204,3.262108e-11, 205,3.315271e-11, 206,3.203489e-11, 207,3.366306e-11, 208,3.452061e-11,
+ 209,3.267528e-11, 210,3.187829e-11, 211,3.391045e-11, 212,3.186204e-11, 213,3.201287e-11, 214,3.136392e-11, 215,3.418431e-11, 216,3.322021e-11,
+ 217,3.416091e-11, 218,3.215629e-11, 219,3.185211e-11, 220,3.380908e-11, 221,3.143693e-11, 222,3.217080e-11, 223,3.193714e-11, 224,3.214646e-11,
+ 225,3.290053e-11, 226,3.256622e-11, 227,3.373305e-11, 228,3.429085e-11, 229,3.253717e-11, 230,3.326557e-11, 231,3.335332e-11, 232,3.244068e-11,
+ 233,3.445272e-11, 234,3.227546e-11, 235,3.321367e-11, 236,3.187832e-11, 237,3.349814e-11, 238,3.393456e-11, 239,3.305570e-11, 240,3.304038e-11,
+ 241,3.226685e-11, 242,3.429870e-11, 243,3.441273e-11, 244,3.205780e-11, 245,3.409545e-11, 246,3.460026e-11, 247,3.151926e-11, 248,3.261460e-11,
+ 249,3.149314e-11, 250,3.424602e-11, 251,3.405845e-11, 252,3.258467e-11)
.param C3ESR=table(run, 1,2.000000e-01, 2,2.000000e-01, 3,2.473696e-01, 4,1.611941e-01, 5,1.974999e-01, 6,1.805777e-01, 7,1.477372e-01, 8,3.101734e-01,
+ 9,2.128885e-01, 10,2.663478e-01, 11,1.951026e-01, 12,2.677770e-01, 13,1.634040e-01, 14,1.889481e-01, 15,3.995760e-01, 16,3.064677e-01,
+ 17,1.846593e-01, 18,3.647765e-01, 19,1.552668e-01, 20,1.500607e-01, 21,2.035830e-01, 22,3.042214e-01, 23,2.963026e-01, 24,2.365727e-01,
+ 25,1.823326e-01, 26,2.388891e-01, 27,1.995386e-01, 28,1.729379e-01, 29,3.947364e-01, 30,2.513496e-01, 31,3.084108e-01, 32,3.824489e-01,
+ 33,2.886737e-01, 34,3.733021e-01, 35,1.184127e-01, 36,2.318860e-01, 37,1.666953e-01, 38,1.157105e-01, 39,3.445257e-01, 40,3.728005e-01,
+ 41,1.649013e-01, 42,1.664979e-01, 43,3.392830e-01, 44,3.751818e-01, 45,3.694654e-01, 46,1.984143e-01, 47,3.971726e-01, 48,2.925730e-01,
+ 49,3.398471e-01, 50,2.362702e-01, 51,2.820972e-01, 52,3.997283e-01, 53,2.779658e-01, 54,1.191687e-01, 55,3.666458e-01, 56,3.039023e-01,
+ 57,1.365290e-01, 58,3.196919e-01, 59,2.574340e-01, 60,3.866097e-01, 61,2.510066e-01, 62,3.031230e-01, 63,3.139596e-01, 64,3.867359e-01,
+ 65,2.293862e-01, 66,1.869347e-01, 67,3.861155e-01, 68,2.189629e-01, 69,2.477804e-01, 70,1.532922e-01, 71,2.625487e-01, 72,2.253622e-01,
+ 73,3.704157e-01, 74,1.030409e-01, 75,2.155682e-01, 76,3.144316e-01, 77,1.030105e-01, 78,3.401291e-01, 79,3.654860e-01, 80,1.677041e-01,
+ 81,1.799771e-01, 82,3.838303e-01, 83,3.477361e-01, 84,2.591172e-01, 85,3.106565e-01, 86,2.021967e-01, 87,3.792245e-01, 88,2.064654e-01,
+ 89,1.886859e-01, 90,1.703805e-01, 91,2.503043e-01, 92,1.847413e-01, 93,2.836452e-01, 94,3.932463e-01, 95,1.308363e-01, 96,1.168458e-01,
+ 97,3.833742e-01, 98,3.455195e-01, 99,3.368400e-01, 100,3.761057e-01, 101,1.477163e-01, 102,1.405913e-01, 103,2.061107e-01, 104,3.729302e-01,
+ 105,3.198758e-01, 106,3.239057e-01, 107,1.034036e-01, 108,2.376487e-01, 109,2.416795e-01, 110,1.274647e-01, 111,3.562688e-01, 112,3.107825e-01,
+ 113,1.879805e-01, 114,1.568754e-01, 115,3.940825e-01, 116,2.043899e-01, 117,3.087366e-01, 118,1.769725e-01, 119,3.919675e-01, 120,1.537381e-01,
+ 121,1.983337e-01, 122,1.482632e-01, 123,1.708202e-01, 124,1.485120e-01, 125,3.131671e-01, 126,2.868940e-01, 127,1.982148e-01, 128,3.632839e-01,
+ 129,1.621812e-01, 130,2.789989e-01, 131,2.204379e-01, 132,2.650797e-01, 133,1.497346e-01, 134,3.759626e-01, 135,2.375453e-01, 136,1.294541e-01,
+ 137,2.183876e-01, 138,1.044158e-01, 139,3.961820e-01, 140,2.200460e-01, 141,3.224632e-01, 142,2.926628e-01, 143,3.453953e-01, 144,3.875664e-01,
+ 145,2.351913e-01, 146,3.162173e-01, 147,1.244049e-01, 148,3.620500e-01, 149,3.110404e-01, 150,1.198976e-01, 151,2.555390e-01, 152,2.572833e-01,
+ 153,2.066055e-01, 154,3.074938e-01, 155,1.162789e-01, 156,2.969812e-01, 157,3.261693e-01, 158,3.239225e-01, 159,2.813707e-01, 160,2.386945e-01,
+ 161,2.596726e-01, 162,3.525768e-01, 163,3.168500e-01, 164,2.774978e-01, 165,3.450891e-01, 166,2.696503e-01, 167,1.521788e-01, 168,2.554018e-01,
+ 169,1.981850e-01, 170,2.013650e-01, 171,1.760528e-01, 172,3.027518e-01, 173,1.440224e-01, 174,2.291544e-01, 175,2.958635e-01, 176,1.808281e-01,
+ 177,3.451459e-01, 178,1.074764e-01, 179,3.028841e-01, 180,1.871472e-01, 181,1.105648e-01, 182,3.476751e-01, 183,1.121174e-01, 184,1.265174e-01,
+ 185,3.111774e-01, 186,2.635012e-01, 187,3.151768e-01, 188,3.589681e-01, 189,2.616619e-01, 190,1.518645e-01, 191,1.487247e-01, 192,1.764796e-01,
+ 193,1.196938e-01, 194,2.598349e-01, 195,1.142064e-01, 196,2.992504e-01, 197,1.977981e-01, 198,3.282559e-01, 199,3.980915e-01, 200,2.702619e-01,
+ 201,3.705345e-01, 202,1.711216e-01, 203,1.377209e-01, 204,1.247061e-01, 205,1.351601e-01, 206,1.529351e-01, 207,2.802546e-01, 208,1.682856e-01,
+ 209,3.317846e-01, 210,3.999186e-01, 211,3.938458e-01, 212,3.781690e-01, 213,2.061237e-01, 214,2.090393e-01, 215,2.932273e-01, 216,1.394789e-01,
+ 217,2.172076e-01, 218,1.904097e-01, 219,2.357661e-01, 220,1.613343e-01, 221,2.860946e-01, 222,3.675025e-01, 223,2.563802e-01, 224,1.281484e-01,
+ 225,1.027368e-01, 226,1.273029e-01, 227,3.689401e-01, 228,3.304935e-01, 229,3.636314e-01, 230,3.723049e-01, 231,2.699266e-01, 232,1.897711e-01,
+ 233,3.124290e-01, 234,1.923453e-01, 235,1.350929e-01, 236,1.274310e-01, 237,2.362392e-01, 238,1.980225e-01, 239,1.713879e-01, 240,3.587947e-01,
+ 241,3.136749e-01, 242,1.841934e-01, 243,1.809065e-01, 244,2.472926e-01, 245,3.656628e-01, 246,2.492737e-01, 247,1.799611e-01, 248,1.876756e-01,
+ 249,1.364415e-01, 250,3.353791e-01, 251,1.796292e-01, 252,2.349553e-01)
.param C3ESL=table(run, 1,1.000000e-09, 2,1.000000e-09, 3,9.720207e-10, 4,6.799352e-10, 5,9.522694e-10, 6,6.722254e-10, 7,7.982949e-10, 8,1.033097e-09,
+ 9,8.868539e-10, 10,7.168943e-10, 11,9.147295e-10, 12,6.033578e-10, 13,9.233376e-10, 14,1.057836e-09, 15,1.090640e-09, 16,8.486235e-10,
+ 17,1.036421e-09, 18,7.709559e-10, 19,8.251065e-10, 20,9.394865e-10, 21,1.165715e-09, 22,1.189332e-09, 23,6.437132e-10, 24,1.027514e-09,
+ 25,8.842490e-10, 26,7.352841e-10, 27,1.032328e-09, 28,7.848558e-10, 29,9.683561e-10, 30,7.251717e-10, 31,7.218160e-10, 32,1.099867e-09,
+ 33,1.032994e-09, 34,9.390336e-10, 35,1.044298e-09, 36,1.047980e-09, 37,1.044475e-09, 38,1.065956e-09, 39,6.784983e-10, 40,9.204011e-10,
+ 41,7.679615e-10, 42,8.198868e-10, 43,9.082668e-10, 44,7.421478e-10, 45,1.090905e-09, 46,8.541940e-10, 47,9.764079e-10, 48,1.173646e-09,
+ 49,7.152129e-10, 50,1.030220e-09, 51,9.611143e-10, 52,6.419622e-10, 53,1.146070e-09, 54,1.174949e-09, 55,8.496860e-10, 56,9.929326e-10,
+ 57,7.236363e-10, 58,9.836992e-10, 59,6.203676e-10, 60,7.980579e-10, 61,1.139956e-09, 62,1.090408e-09, 63,8.550856e-10, 64,9.357657e-10,
+ 65,9.208739e-10, 66,9.505627e-10, 67,1.028725e-09, 68,7.816209e-10, 69,8.843234e-10, 70,7.965125e-10, 71,1.188108e-09, 72,1.072521e-09,
+ 73,6.534487e-10, 74,9.882524e-10, 75,7.374871e-10, 76,6.790913e-10, 77,1.034173e-09, 78,6.939484e-10, 79,7.068614e-10, 80,6.515997e-10,
+ 81,1.119168e-09, 82,8.841558e-10, 83,1.070540e-09, 84,8.756463e-10, 85,1.114826e-09, 86,7.682618e-10, 87,6.277203e-10, 88,6.495276e-10,
+ 89,6.123031e-10, 90,1.170341e-09, 91,7.825000e-10, 92,1.016953e-09, 93,8.423989e-10, 94,1.169083e-09, 95,1.110451e-09, 96,1.133684e-09,
+ 97,1.102328e-09, 98,9.600205e-10, 99,9.999780e-10, 100,1.134715e-09, 101,7.832131e-10, 102,9.600131e-10, 103,8.777703e-10, 104,6.564427e-10,
+ 105,1.121810e-09, 106,8.341917e-10, 107,1.099930e-09, 108,9.760692e-10, 109,7.511631e-10, 110,7.452923e-10, 111,6.588170e-10, 112,6.944947e-10,
+ 113,8.011920e-10, 114,7.314917e-10, 115,8.955206e-10, 116,1.012253e-09, 117,7.241253e-10, 118,1.034171e-09, 119,9.945030e-10, 120,9.147538e-10,
+ 121,8.658626e-10, 122,1.126483e-09, 123,9.648803e-10, 124,9.778474e-10, 125,6.895317e-10, 126,1.115509e-09, 127,8.773624e-10, 128,6.820204e-10,
+ 129,7.005735e-10, 130,8.158909e-10, 131,1.003508e-09, 132,8.140940e-10, 133,7.034503e-10, 134,8.062084e-10, 135,1.137523e-09, 136,1.086043e-09,
+ 137,6.541717e-10, 138,1.159613e-09, 139,6.037105e-10, 140,6.120383e-10, 141,7.408466e-10, 142,7.639987e-10, 143,6.580716e-10, 144,8.419816e-10,
+ 145,9.375872e-10, 146,7.458971e-10, 147,8.681301e-10, 148,1.003092e-09, 149,9.699156e-10, 150,6.564384e-10, 151,7.239128e-10, 152,1.020091e-09,
+ 153,6.418875e-10, 154,8.239062e-10, 155,9.406664e-10, 156,1.017093e-09, 157,8.091178e-10, 158,8.951034e-10, 159,9.946057e-10, 160,1.169225e-09,
+ 161,9.257807e-10, 162,9.178724e-10, 163,6.227095e-10, 164,1.017322e-09, 165,9.710264e-10, 166,8.899565e-10, 167,6.012396e-10, 168,1.018656e-09,
+ 169,8.129191e-10, 170,1.165164e-09, 171,1.009161e-09, 172,7.263943e-10, 173,9.633420e-10, 174,6.585563e-10, 175,7.323054e-10, 176,7.027839e-10,
+ 177,1.175765e-09, 178,9.788724e-10, 179,1.171907e-09, 180,1.107461e-09, 181,8.223036e-10, 182,9.053206e-10, 183,9.923482e-10, 184,8.712053e-10,
+ 185,6.993049e-10, 186,6.524073e-10, 187,7.853366e-10, 188,8.653673e-10, 189,1.082781e-09, 190,1.021208e-09, 191,1.156696e-09, 192,8.405737e-10,
+ 193,8.849583e-10, 194,9.391917e-10, 195,9.481911e-10, 196,1.093816e-09, 197,1.132214e-09, 198,8.835940e-10, 199,7.404136e-10, 200,9.502429e-10,
+ 201,6.380601e-10, 202,1.114692e-09, 203,1.127670e-09, 204,9.436023e-10, 205,1.028975e-09, 206,6.803777e-10, 207,6.239264e-10, 208,7.565532e-10,
+ 209,6.437297e-10, 210,6.407426e-10, 211,7.925959e-10, 212,9.173654e-10, 213,7.560672e-10, 214,6.160907e-10, 215,9.208492e-10, 216,6.627093e-10,
+ 217,6.403835e-10, 218,7.499423e-10, 219,1.090060e-09, 220,9.719598e-10, 221,7.002720e-10, 222,1.103697e-09, 223,1.120634e-09, 224,7.664749e-10,
+ 225,1.133656e-09, 226,7.704849e-10, 227,9.423179e-10, 228,7.111808e-10, 229,9.133679e-10, 230,1.150034e-09, 231,1.133914e-09, 232,8.072661e-10,
+ 233,1.165788e-09, 234,1.195129e-09, 235,1.126987e-09, 236,7.746650e-10, 237,9.898164e-10, 238,9.703584e-10, 239,1.037976e-09, 240,1.142037e-09,
+ 241,7.201540e-10, 242,1.162410e-09, 243,1.041914e-09, 244,1.142850e-09, 245,9.110576e-10, 246,7.778533e-10, 247,6.148400e-10, 248,1.196727e-09,
+ 249,7.597617e-10, 250,6.813376e-10, 251,7.587676e-10, 252,1.144386e-09)
.param C3Lvia=table(run, 1,8.496433e-10, 2,8.496433e-10, 3,1.132189e-09, 4,5.786222e-10, 5,1.047779e-09, 6,1.265828e-09, 7,1.059295e-09, 8,5.469120e-10,
+ 9,1.069039e-09, 10,7.370503e-10, 11,4.932985e-10, 12,7.140493e-10, 13,8.441223e-10, 14,5.605295e-10, 15,4.581814e-10, 16,1.277225e-09,
+ 17,5.738272e-10, 18,7.691099e-10, 19,8.993137e-10, 20,1.025522e-09, 21,3.672722e-10, 22,5.074633e-10, 23,1.122501e-09, 24,6.974118e-10,
+ 25,3.898368e-10, 26,6.567275e-10, 27,1.209708e-09, 28,1.171378e-09, 29,1.217454e-09, 30,8.374879e-10, 31,1.258798e-09, 32,5.932505e-10,
+ 33,1.021189e-09, 34,3.236407e-10, 35,1.052191e-09, 36,8.166309e-10, 37,8.471873e-10, 38,9.189164e-10, 39,9.870740e-10, 40,4.717967e-10,
+ 41,6.877642e-10, 42,6.778626e-10, 43,1.275498e-09, 44,1.142432e-09, 45,1.243143e-09, 46,6.033076e-10, 47,1.000955e-09, 48,6.952684e-10,
+ 49,1.007968e-09, 50,7.746007e-10, 51,1.002821e-09, 52,5.663964e-10, 53,9.571135e-10, 54,3.257958e-10, 55,5.048614e-10, 56,9.249249e-10,
+ 57,5.677339e-10, 58,8.005384e-10, 59,3.979575e-10, 60,2.825988e-10, 61,8.500390e-10, 62,1.066492e-09, 63,4.592171e-10, 64,4.093494e-10,
+ 65,5.994160e-10, 66,6.993136e-10, 67,2.868615e-10, 68,4.292990e-10, 69,4.140565e-10, 70,1.091981e-09, 71,1.292545e-09, 72,1.054322e-09,
+ 73,7.780945e-10, 74,1.058151e-09, 75,6.431369e-10, 76,9.854963e-10, 77,8.135382e-10, 78,8.235032e-10, 79,9.599862e-10, 80,3.845406e-10,
+ 81,9.982189e-10, 82,1.080197e-09, 83,9.218052e-10, 84,1.041359e-09, 85,8.386836e-10, 86,1.164558e-09, 87,6.293285e-10, 88,7.954467e-10,
+ 89,7.388966e-10, 90,1.052957e-09, 91,3.716980e-10, 92,1.096990e-09, 93,8.744555e-10, 94,3.801410e-10, 95,8.256895e-10, 96,7.109369e-10,
+ 97,2.911769e-10, 98,9.041264e-10, 99,5.559280e-10, 100,3.486355e-10, 101,5.006437e-10, 102,8.889454e-10, 103,8.424490e-10, 104,5.135759e-10,
+ 105,4.668723e-10, 106,4.816538e-10, 107,7.281790e-10, 108,9.759029e-10, 109,1.268090e-09, 110,7.478796e-10, 111,3.921366e-10, 112,5.508884e-10,
+ 113,6.096987e-10, 114,9.909800e-10, 115,8.191979e-10, 116,1.106608e-09, 117,1.004029e-09, 118,3.582159e-10, 119,4.267614e-10, 120,8.712798e-10,
+ 121,4.250493e-10, 122,1.278002e-09, 123,9.754300e-10, 124,1.098356e-09, 125,9.012510e-10, 126,8.360394e-10, 127,5.838964e-10, 128,1.167855e-09,
+ 129,1.195169e-09, 130,7.498020e-10, 131,1.244110e-09, 132,1.233676e-09, 133,3.978630e-10, 134,3.435580e-10, 135,1.133904e-09, 136,7.766663e-10,
+ 137,3.907126e-10, 138,1.140662e-09, 139,3.103833e-10, 140,5.282450e-10, 141,4.453545e-10, 142,8.755802e-10, 143,1.240426e-09, 144,8.404136e-10,
+ 145,5.798873e-10, 146,4.217872e-10, 147,7.216960e-10, 148,1.212101e-09, 149,9.650657e-10, 150,9.569177e-10, 151,1.125844e-09, 152,1.007647e-09,
+ 153,1.286223e-09, 154,1.191436e-09, 155,9.988765e-10, 156,8.469373e-10, 157,1.164033e-09, 158,4.352334e-10, 159,8.370972e-10, 160,1.233255e-09,
+ 161,1.188098e-09, 162,3.108491e-10, 163,5.593747e-10, 164,1.009122e-09, 165,8.982965e-10, 166,1.080807e-09, 167,3.310866e-10, 168,1.201467e-09,
+ 169,1.187795e-09, 170,6.546284e-10, 171,1.109733e-09, 172,5.406986e-10, 173,1.245482e-09, 174,1.152525e-09, 175,4.770899e-10, 176,4.715129e-10,
+ 177,1.282023e-09, 178,1.198268e-09, 179,3.648951e-10, 180,1.289790e-09, 181,9.775068e-10, 182,1.284317e-09, 183,9.090624e-10, 184,9.722807e-10,
+ 185,6.105212e-10, 186,6.825065e-10, 187,8.548839e-10, 188,3.420738e-10, 189,5.155426e-10, 190,1.098260e-09, 191,1.137922e-09, 192,4.966164e-10,
+ 193,5.996836e-10, 194,7.918987e-10, 195,6.137024e-10, 196,9.560033e-10, 197,9.648761e-10, 198,8.296308e-10, 199,1.077459e-09, 200,6.361728e-10,
+ 201,1.243847e-09, 202,5.881217e-10, 203,1.110571e-09, 204,7.966340e-10, 205,3.433669e-10, 206,2.753011e-10, 207,8.809821e-10, 208,7.965315e-10,
+ 209,1.279374e-09, 210,1.225970e-09, 211,3.411844e-10, 212,4.759031e-10, 213,4.647994e-10, 214,9.748593e-10, 215,7.695082e-10, 216,5.990629e-10,
+ 217,3.584572e-10, 218,1.139883e-09, 219,9.050358e-10, 220,4.109632e-10, 221,6.538210e-10, 222,5.285160e-10, 223,5.608385e-10, 224,5.623195e-10,
+ 225,1.087668e-09, 226,1.252731e-09, 227,8.165907e-10, 228,3.706905e-10, 229,8.288159e-10, 230,3.605373e-10, 231,4.714129e-10, 232,1.134395e-09,
+ 233,3.098739e-10, 234,7.228005e-10, 235,6.004494e-10, 236,9.322307e-10, 237,5.147375e-10, 238,1.051018e-09, 239,6.068365e-10, 240,7.537063e-10,
+ 241,1.096862e-09, 242,3.942995e-10, 243,3.011082e-10, 244,7.431657e-10, 245,1.278673e-09, 246,7.440171e-10, 247,8.882508e-10, 248,5.639235e-10,
+ 249,1.181523e-09, 250,1.053673e-09, 251,5.183498e-10, 252,9.078099e-10)
.param C3Cpad=table(run, 1,3.489749e-13, 2,3.489749e-13, 3,3.404377e-13, 4,3.520461e-13, 5,4.775913e-13, 6,5.249432e-13, 7,5.050850e-13, 8,2.711723e-13,
+ 9,4.870895e-13, 10,5.225123e-13, 11,3.733058e-13, 12,4.538643e-13, 13,1.945893e-13, 14,1.834014e-13, 15,1.988556e-13, 16,3.531669e-13,
+ 17,4.655169e-13, 18,1.729418e-13, 19,3.779694e-13, 20,4.678779e-13, 21,2.048115e-13, 22,3.471903e-13, 23,5.051488e-13, 24,2.701147e-13,
+ 25,2.570813e-13, 26,1.979605e-13, 27,2.540219e-13, 28,2.879073e-13, 29,2.632266e-13, 30,4.210971e-13, 31,5.128358e-13, 32,3.618018e-13,
+ 33,4.080484e-13, 34,2.336127e-13, 35,2.883772e-13, 36,2.198259e-13, 37,4.455962e-13, 38,3.631768e-13, 39,2.544954e-13, 40,2.703522e-13,
+ 41,4.431373e-13, 42,4.269581e-13, 43,1.801917e-13, 44,5.254449e-13, 45,2.002499e-13, 46,4.264541e-13, 47,4.082004e-13, 48,5.236916e-13,
+ 49,2.766838e-13, 50,3.412705e-13, 51,2.262912e-13, 52,3.576858e-13, 53,4.690293e-13, 54,1.954891e-13, 55,3.757734e-13, 56,3.999167e-13,
+ 57,5.269072e-13, 58,2.013120e-13, 59,4.617514e-13, 60,3.229094e-13, 61,2.548701e-13, 62,3.185723e-13, 63,2.767438e-13, 64,1.931021e-13,
+ 65,3.147369e-13, 66,2.457483e-13, 67,4.237105e-13, 68,4.134701e-13, 69,4.334127e-13, 70,3.306627e-13, 71,3.828486e-13, 72,2.471210e-13,
+ 73,4.112105e-13, 74,3.958402e-13, 75,2.907790e-13, 76,4.025497e-13, 77,1.793588e-13, 78,3.541384e-13, 79,2.916658e-13, 80,4.679395e-13,
+ 81,4.183553e-13, 82,2.780235e-13, 83,1.912604e-13, 84,3.145764e-13, 85,5.042048e-13, 86,4.722234e-13, 87,2.905092e-13, 88,4.507840e-13,
+ 89,3.711084e-13, 90,4.936567e-13, 91,2.634642e-13, 92,1.788447e-13, 93,2.724164e-13, 94,3.806489e-13, 95,1.886887e-13, 96,4.040676e-13,
+ 97,4.146444e-13, 98,4.613220e-13, 99,4.668236e-13, 100,1.877090e-13, 101,3.956133e-13, 102,2.960967e-13, 103,2.085104e-13, 104,4.844792e-13,
+ 105,4.031298e-13, 106,2.564869e-13, 107,2.105977e-13, 108,4.337000e-13, 109,2.726906e-13, 110,3.438441e-13, 111,1.763962e-13, 112,5.109069e-13,
+ 113,4.907038e-13, 114,1.893257e-13, 115,2.960976e-13, 116,3.709048e-13, 117,2.009214e-13, 118,4.496346e-13, 119,4.143980e-13, 120,4.718593e-13,
+ 121,5.038557e-13, 122,2.734846e-13, 123,5.119826e-13, 124,3.466830e-13, 125,3.485864e-13, 126,4.694038e-13, 127,3.493664e-13, 128,2.815627e-13,
+ 129,3.236818e-13, 130,1.738281e-13, 131,5.181549e-13, 132,2.177120e-13, 133,3.374243e-13, 134,1.822740e-13, 135,1.796612e-13, 136,2.074359e-13,
+ 137,5.209365e-13, 138,5.023675e-13, 139,4.691468e-13, 140,2.710970e-13, 141,4.899838e-13, 142,3.795087e-13, 143,5.143837e-13, 144,2.787616e-13,
+ 145,1.704594e-13, 146,5.016703e-13, 147,4.752883e-13, 148,2.097021e-13, 149,4.719117e-13, 150,3.752235e-13, 151,3.212090e-13, 152,3.918444e-13,
+ 153,3.752486e-13, 154,3.628029e-13, 155,1.975278e-13, 156,3.287122e-13, 157,3.660069e-13, 158,4.087117e-13, 159,4.935915e-13, 160,3.738092e-13,
+ 161,3.718776e-13, 162,3.426666e-13, 163,3.076285e-13, 164,4.582629e-13, 165,2.787259e-13, 166,4.900246e-13, 167,3.058777e-13, 168,5.117759e-13,
+ 169,3.055098e-13, 170,4.932203e-13, 171,2.070969e-13, 172,1.942566e-13, 173,2.425085e-13, 174,4.137323e-13, 175,4.418415e-13, 176,3.040263e-13,
+ 177,3.696816e-13, 178,5.016449e-13, 179,2.367431e-13, 180,3.620984e-13, 181,4.370866e-13, 182,4.277801e-13, 183,3.813452e-13, 184,1.997750e-13,
+ 185,5.062160e-13, 186,3.405467e-13, 187,3.841674e-13, 188,3.634884e-13, 189,4.425002e-13, 190,4.942715e-13, 191,4.408499e-13, 192,2.215172e-13,
+ 193,4.583887e-13, 194,3.414627e-13, 195,1.763116e-13, 196,4.073744e-13, 197,4.158753e-13, 198,3.477428e-13, 199,1.973999e-13, 200,3.719556e-13,
+ 201,3.226823e-13, 202,3.268366e-13, 203,3.610818e-13, 204,3.439079e-13, 205,4.135002e-13, 206,3.533082e-13, 207,1.906095e-13, 208,3.153347e-13,
+ 209,2.576066e-13, 210,2.553895e-13, 211,4.587987e-13, 212,4.606688e-13, 213,2.530029e-13, 214,4.351734e-13, 215,4.129897e-13, 216,1.823031e-13,
+ 217,2.198011e-13, 218,2.213666e-13, 219,4.795285e-13, 220,2.170118e-13, 221,1.846749e-13, 222,2.532875e-13, 223,3.852024e-13, 224,3.677835e-13,
+ 225,3.658593e-13, 226,4.251876e-13, 227,5.182266e-13, 228,2.766372e-13, 229,2.848543e-13, 230,1.850308e-13, 231,3.245867e-13, 232,3.008889e-13,
+ 233,5.193832e-13, 234,3.090083e-13, 235,4.121644e-13, 236,4.194865e-13, 237,4.686101e-13, 238,1.694311e-13, 239,3.154799e-13, 240,4.438593e-13,
+ 241,3.420692e-13, 242,4.718540e-13, 243,4.498723e-13, 244,3.688720e-13, 245,3.563161e-13, 246,2.733395e-13, 247,4.773785e-13, 248,4.861923e-13,
+ 249,4.754908e-13, 250,1.806177e-13, 251,2.688420e-13, 252,3.390331e-13)
.param C5C=table(run, 1,3.135000e-11, 2,3.465000e-11, 3,3.256190e-11, 4,3.321136e-11, 5,3.366875e-11, 6,3.319761e-11, 7,3.213743e-11, 8,3.301862e-11,
+ 9,3.384765e-11, 10,3.359816e-11, 11,3.345701e-11, 12,3.376004e-11, 13,3.390228e-11, 14,3.243739e-11, 15,3.277579e-11, 16,3.266308e-11,
+ 17,3.272079e-11, 18,3.358588e-11, 19,3.272537e-11, 20,3.431915e-11, 21,3.379365e-11, 22,3.439048e-11, 23,3.414317e-11, 24,3.331979e-11,
+ 25,3.452352e-11, 26,3.211911e-11, 27,3.458595e-11, 28,3.362212e-11, 29,3.440965e-11, 30,3.226027e-11, 31,3.368649e-11, 32,3.266702e-11,
+ 33,3.315444e-11, 34,3.337154e-11, 35,3.215321e-11, 36,3.323027e-11, 37,3.230624e-11, 38,3.197374e-11, 39,3.365546e-11, 40,3.373426e-11,
+ 41,3.219360e-11, 42,3.185693e-11, 43,3.300307e-11, 44,3.225462e-11, 45,3.259180e-11, 46,3.309610e-11, 47,3.336644e-11, 48,3.172986e-11,
+ 49,3.146390e-11, 50,3.440530e-11, 51,3.306003e-11, 52,3.250250e-11, 53,3.414735e-11, 54,3.420375e-11, 55,3.358114e-11, 56,3.166635e-11,
+ 57,3.176905e-11, 58,3.168799e-11, 59,3.346257e-11, 60,3.429032e-11, 61,3.266715e-11, 62,3.422382e-11, 63,3.355853e-11, 64,3.257205e-11,
+ 65,3.324619e-11, 66,3.277443e-11, 67,3.196108e-11, 68,3.255742e-11, 69,3.391147e-11, 70,3.429547e-11, 71,3.136894e-11, 72,3.142656e-11,
+ 73,3.139607e-11, 74,3.348291e-11, 75,3.366646e-11, 76,3.288426e-11, 77,3.315533e-11, 78,3.416418e-11, 79,3.203072e-11, 80,3.303402e-11,
+ 81,3.357257e-11, 82,3.268664e-11, 83,3.435424e-11, 84,3.411847e-11, 85,3.416839e-11, 86,3.461940e-11, 87,3.297041e-11, 88,3.416484e-11,
+ 89,3.236527e-11, 90,3.440085e-11, 91,3.150250e-11, 92,3.434173e-11, 93,3.140996e-11, 94,3.328983e-11, 95,3.355945e-11, 96,3.243700e-11,
+ 97,3.397619e-11, 98,3.231265e-11, 99,3.208230e-11, 100,3.172472e-11, 101,3.229966e-11, 102,3.137312e-11, 103,3.440573e-11, 104,3.411585e-11,
+ 105,3.190364e-11, 106,3.228407e-11, 107,3.413142e-11, 108,3.276294e-11, 109,3.181888e-11, 110,3.433869e-11, 111,3.190869e-11, 112,3.177016e-11,
+ 113,3.301049e-11, 114,3.292140e-11, 115,3.202060e-11, 116,3.181493e-11, 117,3.330462e-11, 118,3.136312e-11, 119,3.412994e-11, 120,3.250167e-11,
+ 121,3.462166e-11, 122,3.207379e-11, 123,3.252902e-11, 124,3.385186e-11, 125,3.150531e-11, 126,3.395685e-11, 127,3.200432e-11, 128,3.297038e-11,
+ 129,3.326579e-11, 130,3.338365e-11, 131,3.338391e-11, 132,3.226712e-11, 133,3.432302e-11, 134,3.154301e-11, 135,3.155382e-11, 136,3.328656e-11,
+ 137,3.159826e-11, 138,3.418556e-11, 139,3.460598e-11, 140,3.271843e-11, 141,3.430986e-11, 142,3.297854e-11, 143,3.327738e-11, 144,3.387552e-11,
+ 145,3.431121e-11, 146,3.346491e-11, 147,3.142183e-11, 148,3.426599e-11, 149,3.189219e-11, 150,3.407941e-11, 151,3.367158e-11, 152,3.326987e-11,
+ 153,3.352565e-11, 154,3.362056e-11, 155,3.257834e-11, 156,3.198665e-11, 157,3.417084e-11, 158,3.458344e-11, 159,3.203589e-11, 160,3.167610e-11,
+ 161,3.454025e-11, 162,3.141615e-11, 163,3.371825e-11, 164,3.428472e-11, 165,3.394938e-11, 166,3.392636e-11, 167,3.408683e-11, 168,3.176932e-11,
+ 169,3.203883e-11, 170,3.195173e-11, 171,3.364416e-11, 172,3.282721e-11, 173,3.340994e-11, 174,3.148612e-11, 175,3.420093e-11, 176,3.437252e-11,
+ 177,3.186217e-11, 178,3.382562e-11, 179,3.452249e-11, 180,3.456246e-11, 181,3.241317e-11, 182,3.249618e-11, 183,3.388980e-11, 184,3.265568e-11,
+ 185,3.327418e-11, 186,3.422360e-11, 187,3.356785e-11, 188,3.421381e-11, 189,3.425136e-11, 190,3.267658e-11, 191,3.387807e-11, 192,3.249315e-11,
+ 193,3.261186e-11, 194,3.298031e-11, 195,3.421223e-11, 196,3.285033e-11, 197,3.180635e-11, 198,3.198365e-11, 199,3.458248e-11, 200,3.464539e-11,
+ 201,3.141781e-11, 202,3.274411e-11, 203,3.390498e-11, 204,3.397810e-11, 205,3.335489e-11, 206,3.344149e-11, 207,3.391722e-11, 208,3.431275e-11,
+ 209,3.201514e-11, 210,3.458703e-11, 211,3.429425e-11, 212,3.183229e-11, 213,3.366869e-11, 214,3.142406e-11, 215,3.309992e-11, 216,3.160191e-11,
+ 217,3.313824e-11, 218,3.232190e-11, 219,3.215088e-11, 220,3.337855e-11, 221,3.269602e-11, 222,3.307931e-11, 223,3.285933e-11, 224,3.402242e-11,
+ 225,3.437644e-11, 226,3.268894e-11, 227,3.396184e-11, 228,3.373670e-11, 229,3.333380e-11, 230,3.157179e-11, 231,3.212982e-11, 232,3.149020e-11,
+ 233,3.216782e-11, 234,3.421980e-11, 235,3.310702e-11, 236,3.287978e-11, 237,3.243735e-11, 238,3.371158e-11, 239,3.303831e-11, 240,3.278296e-11,
+ 241,3.384335e-11, 242,3.307367e-11, 243,3.186788e-11, 244,3.300368e-11, 245,3.365763e-11, 246,3.375400e-11, 247,3.437053e-11, 248,3.386661e-11,
+ 249,3.276917e-11, 250,3.392234e-11, 251,3.268862e-11, 252,3.445297e-11)
.param C5ESR=table(run, 1,2.000000e-01, 2,2.000000e-01, 3,2.694631e-01, 4,3.749863e-01, 5,1.719879e-01, 6,3.220248e-01, 7,1.987741e-01, 8,3.684463e-01,
+ 9,1.271887e-01, 10,2.021673e-01, 11,3.253655e-01, 12,3.608442e-01, 13,2.436505e-01, 14,1.599609e-01, 15,2.530684e-01, 16,2.411381e-01,
+ 17,1.273466e-01, 18,2.107010e-01, 19,3.790019e-01, 20,3.574012e-01, 21,1.107932e-01, 22,3.519429e-01, 23,2.805801e-01, 24,2.194088e-01,
+ 25,1.494727e-01, 26,3.782428e-01, 27,3.419383e-01, 28,2.605082e-01, 29,1.493486e-01, 30,2.232237e-01, 31,2.349446e-01, 32,2.808800e-01,
+ 33,1.791400e-01, 34,1.073405e-01, 35,2.673296e-01, 36,2.018030e-01, 37,2.970844e-01, 38,2.629035e-01, 39,1.768118e-01, 40,1.908538e-01,
+ 41,3.573915e-01, 42,3.003863e-01, 43,3.568095e-01, 44,3.221466e-01, 45,2.549457e-01, 46,3.470108e-01, 47,2.038598e-01, 48,2.102532e-01,
+ 49,2.122907e-01, 50,1.067698e-01, 51,2.761478e-01, 52,3.121578e-01, 53,1.871381e-01, 54,1.482423e-01, 55,1.096538e-01, 56,2.475713e-01,
+ 57,3.859741e-01, 58,1.128160e-01, 59,2.135851e-01, 60,2.063342e-01, 61,1.591912e-01, 62,3.792671e-01, 63,2.823643e-01, 64,3.651960e-01,
+ 65,1.495342e-01, 66,1.935467e-01, 67,1.821496e-01, 68,3.257914e-01, 69,1.338371e-01, 70,1.837082e-01, 71,3.669282e-01, 72,3.396383e-01,
+ 73,1.513364e-01, 74,1.041231e-01, 75,1.781218e-01, 76,2.704382e-01, 77,1.076431e-01, 78,1.690030e-01, 79,1.938767e-01, 80,2.021772e-01,
+ 81,2.717793e-01, 82,1.764601e-01, 83,2.644529e-01, 84,1.215612e-01, 85,2.238497e-01, 86,3.743229e-01, 87,3.641662e-01, 88,3.245602e-01,
+ 89,1.437424e-01, 90,1.122024e-01, 91,1.638428e-01, 92,3.415560e-01, 93,3.549417e-01, 94,1.147305e-01, 95,3.854004e-01, 96,2.947062e-01,
+ 97,3.262986e-01, 98,2.779964e-01, 99,3.984666e-01, 100,2.392438e-01, 101,1.190129e-01, 102,1.334198e-01, 103,3.881777e-01, 104,1.178532e-01,
+ 105,1.842355e-01, 106,3.936784e-01, 107,1.295979e-01, 108,1.153471e-01, 109,3.647274e-01, 110,1.212627e-01, 111,1.587667e-01, 112,1.521683e-01,
+ 113,3.493366e-01, 114,1.717798e-01, 115,1.531494e-01, 116,3.049849e-01, 117,2.343228e-01, 118,1.222601e-01, 119,1.140156e-01, 120,3.331253e-01,
+ 121,2.869147e-01, 122,1.689766e-01, 123,3.237076e-01, 124,3.964336e-01, 125,2.432811e-01, 126,2.708399e-01, 127,3.612360e-01, 128,3.975806e-01,
+ 129,1.228327e-01, 130,1.033143e-01, 131,1.224232e-01, 132,1.174579e-01, 133,2.926878e-01, 134,3.973777e-01, 135,1.400120e-01, 136,1.523241e-01,
+ 137,1.674280e-01, 138,3.921479e-01, 139,1.939888e-01, 140,1.283539e-01, 141,3.899901e-01, 142,2.307340e-01, 143,1.154115e-01, 144,2.433636e-01,
+ 145,2.453857e-01, 146,2.997705e-01, 147,2.324206e-01, 148,2.319903e-01, 149,3.644098e-01, 150,3.006936e-01, 151,1.649474e-01, 152,1.004015e-01,
+ 153,1.442499e-01, 154,2.621754e-01, 155,2.005278e-01, 156,3.786120e-01, 157,2.493297e-01, 158,3.592776e-01, 159,2.322308e-01, 160,3.319284e-01,
+ 161,1.050260e-01, 162,1.412882e-01, 163,3.687952e-01, 164,1.131594e-01, 165,2.314415e-01, 166,1.779266e-01, 167,3.971736e-01, 168,3.196098e-01,
+ 169,2.968328e-01, 170,3.365333e-01, 171,1.698454e-01, 172,1.984350e-01, 173,2.916392e-01, 174,3.552435e-01, 175,1.043446e-01, 176,3.462922e-01,
+ 177,2.734615e-01, 178,2.707499e-01, 179,1.704321e-01, 180,2.825455e-01, 181,3.613180e-01, 182,1.925358e-01, 183,1.466005e-01, 184,1.656538e-01,
+ 185,1.524552e-01, 186,3.790871e-01, 187,1.469323e-01, 188,2.889191e-01, 189,2.965393e-01, 190,3.079154e-01, 191,2.179157e-01, 192,1.394239e-01,
+ 193,3.796516e-01, 194,3.078846e-01, 195,2.326363e-01, 196,1.945468e-01, 197,1.678453e-01, 198,1.557174e-01, 199,2.433462e-01, 200,3.564445e-01,
+ 201,3.885199e-01, 202,3.407645e-01, 203,1.586605e-01, 204,2.816418e-01, 205,1.709832e-01, 206,2.475744e-01, 207,2.798612e-01, 208,2.388419e-01,
+ 209,1.880084e-01, 210,3.678214e-01, 211,3.886446e-01, 212,2.110013e-01, 213,3.893533e-01, 214,2.946543e-01, 215,2.986720e-01, 216,2.086143e-01,
+ 217,3.558863e-01, 218,2.774410e-01, 219,1.818134e-01, 220,1.720608e-01, 221,3.694771e-01, 222,1.333031e-01, 223,1.695475e-01, 224,1.319452e-01,
+ 225,1.555393e-01, 226,3.041407e-01, 227,2.476857e-01, 228,2.362558e-01, 229,2.420539e-01, 230,1.320749e-01, 231,3.982537e-01, 232,3.263433e-01,
+ 233,1.013777e-01, 234,1.494636e-01, 235,3.748482e-01, 236,2.453193e-01, 237,2.591041e-01, 238,3.074700e-01, 239,3.272080e-01, 240,1.840340e-01,
+ 241,3.056920e-01, 242,2.571840e-01, 243,3.317746e-01, 244,2.848930e-01, 245,1.680652e-01, 246,3.312924e-01, 247,2.801710e-01, 248,1.350684e-01,
+ 249,1.581117e-01, 250,1.123581e-01, 251,3.959762e-01, 252,3.429210e-01)
.param C5ESL=table(run, 1,1.000000e-09, 2,1.000000e-09, 3,9.191371e-10, 4,9.911097e-10, 5,7.917711e-10, 6,1.164116e-09, 7,6.253029e-10, 8,1.148349e-09,
+ 9,8.632410e-10, 10,9.730993e-10, 11,6.883999e-10, 12,7.972294e-10, 13,8.932756e-10, 14,1.169979e-09, 15,9.838273e-10, 16,1.131444e-09,
+ 17,8.160859e-10, 18,9.256693e-10, 19,8.152611e-10, 20,1.111798e-09, 21,1.172729e-09, 22,1.071962e-09, 23,1.109607e-09, 24,8.267663e-10,
+ 25,1.110945e-09, 26,6.730396e-10, 27,9.205404e-10, 28,6.670207e-10, 29,6.971373e-10, 30,6.270882e-10, 31,8.832181e-10, 32,1.182815e-09,
+ 33,1.112926e-09, 34,1.121279e-09, 35,6.126916e-10, 36,8.280467e-10, 37,1.017688e-09, 38,9.994562e-10, 39,1.082708e-09, 40,8.873299e-10,
+ 41,6.234674e-10, 42,6.967656e-10, 43,1.110236e-09, 44,7.434491e-10, 45,9.919593e-10, 46,6.873631e-10, 47,1.063068e-09, 48,6.026608e-10,
+ 49,8.682969e-10, 50,9.629307e-10, 51,9.857372e-10, 52,1.145996e-09, 53,7.984107e-10, 54,1.032563e-09, 55,8.649805e-10, 56,8.401867e-10,
+ 57,1.123859e-09, 58,7.051826e-10, 59,8.917631e-10, 60,6.745579e-10, 61,1.089588e-09, 62,8.817018e-10, 63,1.057732e-09, 64,9.749673e-10,
+ 65,1.068525e-09, 66,7.898562e-10, 67,1.048233e-09, 68,8.650984e-10, 69,1.123180e-09, 70,1.063262e-09, 71,1.073185e-09, 72,8.078196e-10,
+ 73,9.140502e-10, 74,1.147266e-09, 75,8.271055e-10, 76,7.571581e-10, 77,9.471930e-10, 78,7.010064e-10, 79,8.684446e-10, 80,8.413640e-10,
+ 81,8.509207e-10, 82,7.916669e-10, 83,1.157581e-09, 84,6.760098e-10, 85,1.107460e-09, 86,6.226660e-10, 87,6.055525e-10, 88,7.812539e-10,
+ 89,8.746997e-10, 90,8.374865e-10, 91,6.286100e-10, 92,1.108731e-09, 93,6.231838e-10, 94,9.696081e-10, 95,8.941307e-10, 96,8.912614e-10,
+ 97,8.023868e-10, 98,1.015316e-09, 99,8.199910e-10, 100,8.341765e-10, 101,1.164725e-09, 102,8.250921e-10, 103,8.859511e-10, 104,8.503720e-10,
+ 105,9.191285e-10, 106,9.690189e-10, 107,7.522162e-10, 108,9.283611e-10, 109,6.858296e-10, 110,9.292222e-10, 111,9.017464e-10, 112,8.728171e-10,
+ 113,9.220040e-10, 114,1.123103e-09, 115,8.670471e-10, 116,6.523496e-10, 117,7.732880e-10, 118,9.770086e-10, 119,9.298438e-10, 120,6.923280e-10,
+ 121,7.822254e-10, 122,7.644964e-10, 123,6.078122e-10, 124,6.846953e-10, 125,6.306972e-10, 126,7.281744e-10, 127,1.003211e-09, 128,6.947011e-10,
+ 129,7.696776e-10, 130,9.845994e-10, 131,8.917681e-10, 132,7.378572e-10, 133,8.196005e-10, 134,9.869804e-10, 135,1.055137e-09, 136,1.013317e-09,
+ 137,1.053370e-09, 138,8.887123e-10, 139,8.363894e-10, 140,8.543930e-10, 141,6.612605e-10, 142,7.375243e-10, 143,8.936853e-10, 144,6.195242e-10,
+ 145,6.503422e-10, 146,8.813870e-10, 147,9.472623e-10, 148,6.631495e-10, 149,1.199450e-09, 150,6.730737e-10, 151,8.854713e-10, 152,1.083347e-09,
+ 153,6.713019e-10, 154,6.737838e-10, 155,7.972982e-10, 156,9.434359e-10, 157,8.180866e-10, 158,8.438946e-10, 159,8.737749e-10, 160,9.989617e-10,
+ 161,8.009708e-10, 162,1.015661e-09, 163,9.076196e-10, 164,8.112851e-10, 165,7.524069e-10, 166,7.562598e-10, 167,9.949070e-10, 168,7.400407e-10,
+ 169,1.070116e-09, 170,1.130738e-09, 171,9.999293e-10, 172,7.892028e-10, 173,1.094727e-09, 174,1.030334e-09, 175,9.863776e-10, 176,7.955406e-10,
+ 177,8.322908e-10, 178,1.184224e-09, 179,6.699537e-10, 180,1.002860e-09, 181,1.051236e-09, 182,8.982500e-10, 183,1.035048e-09, 184,1.077637e-09,
+ 185,1.045580e-09, 186,1.093927e-09, 187,8.703900e-10, 188,9.691432e-10, 189,1.130112e-09, 190,7.106933e-10, 191,6.493801e-10, 192,7.338017e-10,
+ 193,9.793868e-10, 194,8.267581e-10, 195,8.652903e-10, 196,1.133152e-09, 197,1.050555e-09, 198,1.160147e-09, 199,8.871670e-10, 200,9.663499e-10,
+ 201,7.926608e-10, 202,1.013996e-09, 203,7.463313e-10, 204,1.090686e-09, 205,1.042041e-09, 206,8.354426e-10, 207,7.906040e-10, 208,1.101791e-09,
+ 209,7.761468e-10, 210,6.012212e-10, 211,9.848502e-10, 212,1.075230e-09, 213,6.848859e-10, 214,6.167680e-10, 215,7.977865e-10, 216,1.169514e-09,
+ 217,8.913568e-10, 218,6.441939e-10, 219,1.118054e-09, 220,9.228572e-10, 221,7.467328e-10, 222,7.625440e-10, 223,1.065218e-09, 224,9.803116e-10,
+ 225,1.184568e-09, 226,6.114224e-10, 227,7.409521e-10, 228,7.874352e-10, 229,1.130039e-09, 230,7.356706e-10, 231,7.064001e-10, 232,1.077020e-09,
+ 233,7.395186e-10, 234,9.777890e-10, 235,1.016349e-09, 236,9.544989e-10, 237,1.063837e-09, 238,1.182126e-09, 239,6.236695e-10, 240,8.571313e-10,
+ 241,7.866865e-10, 242,6.446667e-10, 243,7.313085e-10, 244,1.171003e-09, 245,1.018226e-09, 246,8.099814e-10, 247,6.623730e-10, 248,1.060816e-09,
+ 249,6.331909e-10, 250,8.138024e-10, 251,9.188081e-10, 252,8.563225e-10)
.param C5Lvia=table(run, 1,8.496433e-10, 2,8.496433e-10, 3,1.167710e-09, 4,7.942717e-10, 5,8.910348e-10, 6,1.253336e-09, 7,1.061724e-09, 8,9.241363e-10,
+ 9,1.208778e-09, 10,4.018321e-10, 11,4.499062e-10, 12,1.005451e-09, 13,1.152325e-09, 14,7.124101e-10, 15,3.233148e-10, 16,3.787355e-10,
+ 17,4.459919e-10, 18,1.272516e-09, 19,9.691503e-10, 20,1.203439e-09, 21,9.003717e-10, 22,7.946417e-10, 23,5.879941e-10, 24,6.516111e-10,
+ 25,6.099420e-10, 26,1.137634e-09, 27,5.316154e-10, 28,8.428493e-10, 29,6.435452e-10, 30,4.922445e-10, 31,4.521890e-10, 32,4.333671e-10,
+ 33,1.243441e-09, 34,8.708432e-10, 35,3.054343e-10, 36,9.263994e-10, 37,6.773829e-10, 38,5.730582e-10, 39,5.453881e-10, 40,9.638034e-10,
+ 41,9.562129e-10, 42,5.659789e-10, 43,5.973477e-10, 44,9.159594e-10, 45,8.824992e-10, 46,1.212681e-09, 47,1.027568e-09, 48,7.719347e-10,
+ 49,8.621981e-10, 50,8.064494e-10, 51,1.214385e-09, 52,4.878494e-10, 53,4.689977e-10, 54,8.060980e-10, 55,6.354205e-10, 56,4.645635e-10,
+ 57,8.073368e-10, 58,3.463769e-10, 59,3.495311e-10, 60,8.517725e-10, 61,1.145008e-09, 62,1.169283e-09, 63,1.197251e-09, 64,6.320774e-10,
+ 65,8.743946e-10, 66,8.398615e-10, 67,1.183429e-09, 68,4.299094e-10, 69,1.000852e-09, 70,3.058025e-10, 71,5.152995e-10, 72,6.715884e-10,
+ 73,4.302290e-10, 74,1.014592e-09, 75,5.820754e-10, 76,8.187091e-10, 77,6.601421e-10, 78,4.320776e-10, 79,1.230018e-09, 80,7.036617e-10,
+ 81,6.264642e-10, 82,8.946788e-10, 83,1.291939e-09, 84,1.045090e-09, 85,5.913665e-10, 86,9.377755e-10, 87,2.888946e-10, 88,4.717010e-10,
+ 89,1.062751e-09, 90,4.194943e-10, 91,7.632228e-10, 92,1.239783e-09, 93,1.041061e-09, 94,8.776905e-10, 95,6.064960e-10, 96,3.646181e-10,
+ 97,5.402191e-10, 98,1.013366e-09, 99,5.713238e-10, 100,1.060562e-09, 101,1.181306e-09, 102,9.554085e-10, 103,7.557625e-10, 104,7.226928e-10,
+ 105,5.624926e-10, 106,1.197025e-09, 107,3.955616e-10, 108,1.003410e-09, 109,7.439859e-10, 110,4.508785e-10, 111,1.270604e-09, 112,3.674321e-10,
+ 113,6.754729e-10, 114,1.006050e-09, 115,9.212782e-10, 116,8.999495e-10, 117,1.260225e-09, 118,9.804785e-10, 119,5.189839e-10, 120,1.071925e-09,
+ 121,5.356608e-10, 122,7.315158e-10, 123,4.957687e-10, 124,5.064747e-10, 125,1.250972e-09, 126,7.909724e-10, 127,6.656364e-10, 128,3.135183e-10,
+ 129,8.384408e-10, 130,6.847317e-10, 131,5.875369e-10, 132,1.143170e-09, 133,6.188455e-10, 134,9.503811e-10, 135,1.032000e-09, 136,1.233144e-09,
+ 137,4.456749e-10, 138,1.044359e-09, 139,5.328677e-10, 140,9.206154e-10, 141,1.234527e-09, 142,1.027119e-09, 143,9.373972e-10, 144,8.557927e-10,
+ 145,4.133419e-10, 146,6.650916e-10, 147,8.388326e-10, 148,1.194819e-09, 149,1.195687e-09, 150,7.456452e-10, 151,8.334947e-10, 152,8.968503e-10,
+ 153,7.823597e-10, 154,3.450603e-10, 155,3.926401e-10, 156,6.800806e-10, 157,3.265397e-10, 158,8.260801e-10, 159,6.460771e-10, 160,6.275223e-10,
+ 161,1.098844e-09, 162,9.976066e-10, 163,9.769131e-10, 164,1.123137e-09, 165,1.090833e-09, 166,2.980030e-10, 167,2.897350e-10, 168,5.295813e-10,
+ 169,3.296662e-10, 170,9.578127e-10, 171,1.145356e-09, 172,6.722242e-10, 173,2.856001e-10, 174,6.290160e-10, 175,9.626444e-10, 176,1.234710e-09,
+ 177,8.854600e-10, 178,1.171087e-09, 179,1.204241e-09, 180,8.835342e-10, 181,6.654192e-10, 182,2.784200e-10, 183,9.541918e-10, 184,7.559267e-10,
+ 185,1.103626e-09, 186,1.004817e-09, 187,4.766516e-10, 188,7.698862e-10, 189,1.086015e-09, 190,3.301151e-10, 191,5.106298e-10, 192,4.094122e-10,
+ 193,6.786700e-10, 194,1.033543e-09, 195,1.181685e-09, 196,2.752174e-10, 197,8.679355e-10, 198,7.246635e-10, 199,1.030202e-09, 200,6.472623e-10,
+ 201,7.960590e-10, 202,9.860348e-10, 203,6.477092e-10, 204,9.587290e-10, 205,8.034944e-10, 206,1.032838e-09, 207,6.894771e-10, 208,6.560343e-10,
+ 209,9.711308e-10, 210,8.907734e-10, 211,5.974480e-10, 212,3.070216e-10, 213,7.948853e-10, 214,7.062293e-10, 215,4.499864e-10, 216,1.018170e-09,
+ 217,9.845997e-10, 218,7.906566e-10, 219,8.298379e-10, 220,1.225013e-09, 221,1.132144e-09, 222,3.609893e-10, 223,6.408556e-10, 224,8.767078e-10,
+ 225,7.257773e-10, 226,4.148140e-10, 227,1.200690e-09, 228,1.053035e-09, 229,8.562233e-10, 230,9.750974e-10, 231,1.003390e-09, 232,3.727782e-10,
+ 233,8.934441e-10, 234,7.739391e-10, 235,1.264587e-09, 236,4.816576e-10, 237,9.463306e-10, 238,7.480447e-10, 239,6.178958e-10, 240,7.393053e-10,
+ 241,3.586758e-10, 242,3.687418e-10, 243,8.395095e-10, 244,8.709021e-10, 245,1.216016e-09, 246,7.900349e-10, 247,1.280262e-09, 248,1.046739e-09,
+ 249,3.083640e-10, 250,5.337174e-10, 251,1.001438e-09, 252,7.909830e-10)
.param C5Cpad=table(run, 1,3.489749e-13, 2,3.489749e-13, 3,5.168761e-13, 4,4.507272e-13, 5,4.698262e-13, 6,4.562317e-13, 7,2.262763e-13, 8,2.346470e-13,
+ 9,2.266836e-13, 10,5.174347e-13, 11,3.305744e-13, 12,2.322251e-13, 13,3.425398e-13, 14,2.797452e-13, 15,3.720763e-13, 16,1.959239e-13,
+ 17,1.804618e-13, 18,4.039367e-13, 19,3.083225e-13, 20,3.350167e-13, 21,3.097591e-13, 22,4.590581e-13, 23,2.019498e-13, 24,3.619325e-13,
+ 25,5.125529e-13, 26,4.608457e-13, 27,5.207955e-13, 28,3.637355e-13, 29,4.822015e-13, 30,3.740511e-13, 31,4.949188e-13, 32,2.978737e-13,
+ 33,4.281529e-13, 34,1.774887e-13, 35,1.851020e-13, 36,3.598889e-13, 37,4.918744e-13, 38,3.537271e-13, 39,4.570865e-13, 40,2.989113e-13,
+ 41,2.755822e-13, 42,5.181407e-13, 43,2.381281e-13, 44,5.228979e-13, 45,3.315154e-13, 46,3.957435e-13, 47,3.047611e-13, 48,1.825072e-13,
+ 49,4.431654e-13, 50,3.159425e-13, 51,1.710505e-13, 52,4.578716e-13, 53,3.336368e-13, 54,3.967250e-13, 55,4.276189e-13, 56,3.765953e-13,
+ 57,4.892640e-13, 58,2.025813e-13, 59,2.124841e-13, 60,2.726294e-13, 61,2.593253e-13, 62,1.794024e-13, 63,2.906382e-13, 64,2.950066e-13,
+ 65,4.873776e-13, 66,2.218088e-13, 67,4.916908e-13, 68,3.430533e-13, 69,5.083754e-13, 70,2.615530e-13, 71,3.542011e-13, 72,1.832582e-13,
+ 73,2.149450e-13, 74,3.708443e-13, 75,3.763293e-13, 76,3.589880e-13, 77,2.984573e-13, 78,3.316462e-13, 79,4.699730e-13, 80,4.796412e-13,
+ 81,4.566896e-13, 82,4.449968e-13, 83,3.473095e-13, 84,2.421613e-13, 85,3.049229e-13, 86,2.891014e-13, 87,2.766048e-13, 88,5.002898e-13,
+ 89,3.742680e-13, 90,4.504487e-13, 91,5.157723e-13, 92,4.405769e-13, 93,5.015394e-13, 94,5.239664e-13, 95,2.136457e-13, 96,4.176548e-13,
+ 97,4.240860e-13, 98,4.902641e-13, 99,2.711069e-13, 100,4.268733e-13, 101,3.748733e-13, 102,3.745319e-13, 103,4.466248e-13, 104,2.704363e-13,
+ 105,4.560943e-13, 106,3.583545e-13, 107,3.016062e-13, 108,2.423491e-13, 109,4.479196e-13, 110,2.478491e-13, 111,4.488225e-13, 112,4.038585e-13,
+ 113,2.565166e-13, 114,4.272179e-13, 115,3.296821e-13, 116,4.413396e-13, 117,4.388725e-13, 118,4.016735e-13, 119,2.041972e-13, 120,3.046327e-13,
+ 121,1.913333e-13, 122,4.933852e-13, 123,2.085489e-13, 124,4.574055e-13, 125,4.953765e-13, 126,2.551282e-13, 127,2.834083e-13, 128,3.409428e-13,
+ 129,5.136183e-13, 130,2.090400e-13, 131,2.282678e-13, 132,3.481372e-13, 133,2.895768e-13, 134,2.390231e-13, 135,4.590129e-13, 136,2.623053e-13,
+ 137,1.686390e-13, 138,2.166599e-13, 139,2.966813e-13, 140,1.909143e-13, 141,2.228319e-13, 142,3.029876e-13, 143,3.379106e-13, 144,3.673263e-13,
+ 145,2.494421e-13, 146,3.424901e-13, 147,4.429600e-13, 148,3.548612e-13, 149,2.759309e-13, 150,4.573383e-13, 151,1.977079e-13, 152,3.910029e-13,
+ 153,4.999125e-13, 154,2.174924e-13, 155,3.842299e-13, 156,2.436038e-13, 157,4.107642e-13, 158,1.754872e-13, 159,2.027368e-13, 160,3.584092e-13,
+ 161,2.110677e-13, 162,2.583977e-13, 163,2.140596e-13, 164,4.812431e-13, 165,4.200022e-13, 166,4.484526e-13, 167,5.135627e-13, 168,4.715333e-13,
+ 169,3.261447e-13, 170,2.245680e-13, 171,4.339395e-13, 172,2.488095e-13, 173,1.998031e-13, 174,3.626030e-13, 175,3.171256e-13, 176,1.697578e-13,
+ 177,4.318349e-13, 178,2.824971e-13, 179,4.752641e-13, 180,2.824965e-13, 181,4.855254e-13, 182,2.985614e-13, 183,2.335879e-13, 184,2.146159e-13,
+ 185,3.025040e-13, 186,4.054595e-13, 187,5.013355e-13, 188,3.556952e-13, 189,4.446706e-13, 190,4.772870e-13, 191,5.118461e-13, 192,1.780238e-13,
+ 193,1.914077e-13, 194,4.811513e-13, 195,4.394801e-13, 196,4.441824e-13, 197,4.388871e-13, 198,4.480255e-13, 199,2.226833e-13, 200,4.707911e-13,
+ 201,5.030902e-13, 202,2.442325e-13, 203,4.377522e-13, 204,1.781508e-13, 205,5.105557e-13, 206,4.925570e-13, 207,3.970891e-13, 208,4.973779e-13,
+ 209,2.096050e-13, 210,5.068177e-13, 211,2.031199e-13, 212,3.130761e-13, 213,4.239814e-13, 214,2.907075e-13, 215,3.598795e-13, 216,3.949498e-13,
+ 217,3.771677e-13, 218,3.531556e-13, 219,1.691420e-13, 220,4.130040e-13, 221,4.042180e-13, 222,2.640753e-13, 223,4.805856e-13, 224,2.442332e-13,
+ 225,3.174354e-13, 226,4.241063e-13, 227,1.749783e-13, 228,1.840516e-13, 229,1.924831e-13, 230,2.505329e-13, 231,4.838926e-13, 232,2.518791e-13,
+ 233,4.895953e-13, 234,4.922348e-13, 235,4.574632e-13, 236,1.849363e-13, 237,2.944847e-13, 238,5.079937e-13, 239,3.546075e-13, 240,2.973585e-13,
+ 241,3.402779e-13, 242,2.001867e-13, 243,2.581252e-13, 244,4.603480e-13, 245,4.650924e-13, 246,2.661871e-13, 247,5.146760e-13, 248,1.747601e-13,
+ 249,3.165889e-13, 250,3.379895e-13, 251,2.182833e-13, 252,4.824236e-13)
.param C7C=table(run, 1,1.710000e-11, 2,1.890000e-11, 3,1.816735e-11, 4,1.841441e-11, 5,1.715055e-11, 6,1.806363e-11, 7,1.784758e-11, 8,1.768061e-11,
+ 9,1.721761e-11, 10,1.786277e-11, 11,1.710461e-11, 12,1.825470e-11, 13,1.760171e-11, 14,1.831409e-11, 15,1.869957e-11, 16,1.825428e-11,
+ 17,1.747105e-11, 18,1.846006e-11, 19,1.838563e-11, 20,1.716925e-11, 21,1.764171e-11, 22,1.711328e-11, 23,1.878403e-11, 24,1.739754e-11,
+ 25,1.770845e-11, 26,1.879639e-11, 27,1.711767e-11, 28,1.734908e-11, 29,1.867534e-11, 30,1.871061e-11, 31,1.862644e-11, 32,1.853146e-11,
+ 33,1.888477e-11, 34,1.852788e-11, 35,1.823494e-11, 36,1.774642e-11, 37,1.825314e-11, 38,1.863241e-11, 39,1.730945e-11, 40,1.799930e-11,
+ 41,1.796233e-11, 42,1.750962e-11, 43,1.794057e-11, 44,1.864053e-11, 45,1.837910e-11, 46,1.816930e-11, 47,1.861128e-11, 48,1.750751e-11,
+ 49,1.737928e-11, 50,1.869391e-11, 51,1.785839e-11, 52,1.777712e-11, 53,1.728424e-11, 54,1.870342e-11, 55,1.777365e-11, 56,1.756595e-11,
+ 57,1.720538e-11, 58,1.821149e-11, 59,1.808797e-11, 60,1.727581e-11, 61,1.784342e-11, 62,1.759959e-11, 63,1.712034e-11, 64,1.772554e-11,
+ 65,1.760783e-11, 66,1.712695e-11, 67,1.714566e-11, 68,1.795064e-11, 69,1.748614e-11, 70,1.805194e-11, 71,1.781802e-11, 72,1.838189e-11,
+ 73,1.871548e-11, 74,1.742401e-11, 75,1.724782e-11, 76,1.864741e-11, 77,1.729536e-11, 78,1.757329e-11, 79,1.757322e-11, 80,1.780169e-11,
+ 81,1.818440e-11, 82,1.826678e-11, 83,1.882356e-11, 84,1.762414e-11, 85,1.738674e-11, 86,1.741118e-11, 87,1.848855e-11, 88,1.831369e-11,
+ 89,1.757965e-11, 90,1.750600e-11, 91,1.796651e-11, 92,1.788082e-11, 93,1.883768e-11, 94,1.828552e-11, 95,1.741856e-11, 96,1.730088e-11,
+ 97,1.797664e-11, 98,1.726476e-11, 99,1.782716e-11, 100,1.717805e-11, 101,1.725691e-11, 102,1.810573e-11, 103,1.718292e-11, 104,1.826062e-11,
+ 105,1.714118e-11, 106,1.786254e-11, 107,1.712802e-11, 108,1.785472e-11, 109,1.838901e-11, 110,1.770456e-11, 111,1.865796e-11, 112,1.733212e-11,
+ 113,1.778616e-11, 114,1.727547e-11, 115,1.810111e-11, 116,1.769641e-11, 117,1.757317e-11, 118,1.772551e-11, 119,1.839106e-11, 120,1.787273e-11,
+ 121,1.885260e-11, 122,1.877049e-11, 123,1.756579e-11, 124,1.719551e-11, 125,1.780450e-11, 126,1.805283e-11, 127,1.826765e-11, 128,1.837069e-11,
+ 129,1.782626e-11, 130,1.785028e-11, 131,1.859841e-11, 132,1.758470e-11, 133,1.798129e-11, 134,1.866140e-11, 135,1.777563e-11, 136,1.747274e-11,
+ 137,1.768558e-11, 138,1.714113e-11, 139,1.750627e-11, 140,1.734432e-11, 141,1.751151e-11, 142,1.750608e-11, 143,1.801022e-11, 144,1.848420e-11,
+ 145,1.789102e-11, 146,1.834855e-11, 147,1.794056e-11, 148,1.840714e-11, 149,1.824727e-11, 150,1.746944e-11, 151,1.809078e-11, 152,1.772690e-11,
+ 153,1.766995e-11, 154,1.774658e-11, 155,1.746116e-11, 156,1.718047e-11, 157,1.815843e-11, 158,1.761995e-11, 159,1.757005e-11, 160,1.843214e-11,
+ 161,1.806381e-11, 162,1.805070e-11, 163,1.712718e-11, 164,1.751631e-11, 165,1.740442e-11, 166,1.783176e-11, 167,1.819802e-11, 168,1.805506e-11,
+ 169,1.842786e-11, 170,1.759513e-11, 171,1.769228e-11, 172,1.887170e-11, 173,1.867937e-11, 174,1.887622e-11, 175,1.865081e-11, 176,1.757879e-11,
+ 177,1.815312e-11, 178,1.732959e-11, 179,1.730648e-11, 180,1.863323e-11, 181,1.817026e-11, 182,1.735611e-11, 183,1.759712e-11, 184,1.839807e-11,
+ 185,1.785373e-11, 186,1.824191e-11, 187,1.776023e-11, 188,1.778431e-11, 189,1.743922e-11, 190,1.825168e-11, 191,1.806682e-11, 192,1.860084e-11,
+ 193,1.730322e-11, 194,1.722506e-11, 195,1.840198e-11, 196,1.867830e-11, 197,1.824579e-11, 198,1.765906e-11, 199,1.722799e-11, 200,1.767074e-11,
+ 201,1.788551e-11, 202,1.715254e-11, 203,1.754630e-11, 204,1.851427e-11, 205,1.725817e-11, 206,1.846009e-11, 207,1.742972e-11, 208,1.861162e-11,
+ 209,1.810640e-11, 210,1.873185e-11, 211,1.846305e-11, 212,1.762646e-11, 213,1.818455e-11, 214,1.711168e-11, 215,1.887085e-11, 216,1.731142e-11,
+ 217,1.794916e-11, 218,1.815379e-11, 219,1.722735e-11, 220,1.749792e-11, 221,1.751050e-11, 222,1.757451e-11, 223,1.778173e-11, 224,1.781675e-11,
+ 225,1.876965e-11, 226,1.873669e-11, 227,1.768963e-11, 228,1.822914e-11, 229,1.883431e-11, 230,1.842770e-11, 231,1.724849e-11, 232,1.769318e-11,
+ 233,1.775523e-11, 234,1.738742e-11, 235,1.821695e-11, 236,1.775099e-11, 237,1.760943e-11, 238,1.811106e-11, 239,1.863192e-11, 240,1.872440e-11,
+ 241,1.764048e-11, 242,1.849230e-11, 243,1.830034e-11, 244,1.840068e-11, 245,1.729107e-11, 246,1.754213e-11, 247,1.767266e-11, 248,1.827984e-11,
+ 249,1.844968e-11, 250,1.866711e-11, 251,1.787675e-11, 252,1.715185e-11)
.param C7ESR=table(run, 1,2.000000e-01, 2,2.000000e-01, 3,2.806136e-01, 4,3.394458e-01, 5,2.400637e-01, 6,1.109383e-01, 7,1.574643e-01, 8,2.476038e-01,
+ 9,3.767089e-01, 10,3.979888e-01, 11,3.298272e-01, 12,3.913180e-01, 13,3.018413e-01, 14,3.813950e-01, 15,2.628602e-01, 16,3.780203e-01,
+ 17,1.374394e-01, 18,2.741614e-01, 19,3.590633e-01, 20,3.915950e-01, 21,2.746557e-01, 22,2.425212e-01, 23,3.158679e-01, 24,3.719259e-01,
+ 25,1.504559e-01, 26,2.967883e-01, 27,2.366005e-01, 28,3.264010e-01, 29,2.790828e-01, 30,2.907389e-01, 31,2.097245e-01, 32,1.695001e-01,
+ 33,1.727992e-01, 34,2.302408e-01, 35,2.924987e-01, 36,1.565054e-01, 37,3.468176e-01, 38,1.079807e-01, 39,1.554493e-01, 40,2.096051e-01,
+ 41,2.974362e-01, 42,3.134367e-01, 43,1.477840e-01, 44,1.202049e-01, 45,1.262708e-01, 46,1.395349e-01, 47,3.749084e-01, 48,1.201992e-01,
+ 49,3.584672e-01, 50,3.934648e-01, 51,1.397590e-01, 52,3.754594e-01, 53,2.996108e-01, 54,3.246499e-01, 55,2.320229e-01, 56,2.849242e-01,
+ 57,3.979034e-01, 58,3.862465e-01, 59,1.493704e-01, 60,2.946922e-01, 61,3.707204e-01, 62,3.957316e-01, 63,1.681098e-01, 64,2.926989e-01,
+ 65,1.012377e-01, 66,2.148068e-01, 67,2.796039e-01, 68,1.178149e-01, 69,3.048660e-01, 70,3.586778e-01, 71,2.692280e-01, 72,3.154075e-01,
+ 73,3.781121e-01, 74,3.889301e-01, 75,1.661244e-01, 76,1.375582e-01, 77,3.489245e-01, 78,1.649623e-01, 79,2.682983e-01, 80,2.198546e-01,
+ 81,2.220884e-01, 82,3.341129e-01, 83,3.287599e-01, 84,1.374207e-01, 85,3.884275e-01, 86,1.559686e-01, 87,3.529940e-01, 88,1.245036e-01,
+ 89,2.681584e-01, 90,3.532056e-01, 91,2.601396e-01, 92,3.985716e-01, 93,1.533540e-01, 94,1.939672e-01, 95,1.540099e-01, 96,2.904077e-01,
+ 97,3.943453e-01, 98,1.417098e-01, 99,3.963639e-01, 100,1.123705e-01, 101,3.238928e-01, 102,3.119251e-01, 103,1.183874e-01, 104,1.670614e-01,
+ 105,3.084957e-01, 106,3.244792e-01, 107,2.308615e-01, 108,3.220784e-01, 109,2.022786e-01, 110,2.438557e-01, 111,3.887610e-01, 112,2.676792e-01,
+ 113,1.664776e-01, 114,3.787050e-01, 115,3.626938e-01, 116,3.862985e-01, 117,2.672572e-01, 118,3.458656e-01, 119,1.369529e-01, 120,3.707698e-01,
+ 121,3.123053e-01, 122,2.632324e-01, 123,3.633287e-01, 124,3.556207e-01, 125,2.071201e-01, 126,1.857713e-01, 127,2.176762e-01, 128,3.547357e-01,
+ 129,3.339422e-01, 130,3.745553e-01, 131,3.561623e-01, 132,3.176677e-01, 133,2.570009e-01, 134,3.108670e-01, 135,3.032474e-01, 136,3.951344e-01,
+ 137,1.628183e-01, 138,3.106386e-01, 139,1.016111e-01, 140,1.373093e-01, 141,1.510927e-01, 142,3.417823e-01, 143,2.040845e-01, 144,1.552902e-01,
+ 145,1.208402e-01, 146,3.886513e-01, 147,2.938939e-01, 148,2.533305e-01, 149,2.585671e-01, 150,3.184787e-01, 151,3.356828e-01, 152,1.981421e-01,
+ 153,3.432154e-01, 154,2.597092e-01, 155,3.423493e-01, 156,2.580774e-01, 157,3.165467e-01, 158,2.926112e-01, 159,1.622443e-01, 160,1.140121e-01,
+ 161,2.991494e-01, 162,1.276683e-01, 163,1.863201e-01, 164,1.939983e-01, 165,1.124179e-01, 166,1.227801e-01, 167,1.314099e-01, 168,1.289519e-01,
+ 169,2.247011e-01, 170,3.684990e-01, 171,1.057755e-01, 172,3.918953e-01, 173,2.865478e-01, 174,1.338599e-01, 175,1.250715e-01, 176,2.688218e-01,
+ 177,3.421354e-01, 178,2.507038e-01, 179,2.453890e-01, 180,2.691387e-01, 181,3.376733e-01, 182,2.679554e-01, 183,3.057724e-01, 184,2.660136e-01,
+ 185,2.411165e-01, 186,1.779569e-01, 187,1.976678e-01, 188,2.551912e-01, 189,3.413238e-01, 190,1.486998e-01, 191,1.109477e-01, 192,1.134613e-01,
+ 193,1.232599e-01, 194,2.858154e-01, 195,2.223505e-01, 196,2.184077e-01, 197,3.484221e-01, 198,2.202340e-01, 199,1.174908e-01, 200,2.274314e-01,
+ 201,3.772763e-01, 202,1.387341e-01, 203,2.227005e-01, 204,3.022756e-01, 205,2.761821e-01, 206,3.176374e-01, 207,3.914634e-01, 208,2.061579e-01,
+ 209,2.131498e-01, 210,1.966155e-01, 211,2.299532e-01, 212,1.976391e-01, 213,1.064219e-01, 214,3.358587e-01, 215,3.795880e-01, 216,1.922033e-01,
+ 217,3.898705e-01, 218,1.225284e-01, 219,1.717994e-01, 220,1.324975e-01, 221,3.487422e-01, 222,3.594101e-01, 223,1.575132e-01, 224,2.543924e-01,
+ 225,3.018037e-01, 226,3.885469e-01, 227,3.534446e-01, 228,2.078570e-01, 229,2.118649e-01, 230,2.059102e-01, 231,2.520103e-01, 232,3.636851e-01,
+ 233,1.896763e-01, 234,2.372203e-01, 235,3.444896e-01, 236,3.569789e-01, 237,2.453648e-01, 238,1.835854e-01, 239,2.066433e-01, 240,2.568748e-01,
+ 241,2.499642e-01, 242,1.158605e-01, 243,3.148603e-01, 244,1.151909e-01, 245,2.507198e-01, 246,3.716422e-01, 247,1.804873e-01, 248,1.051422e-01,
+ 249,3.887533e-01, 250,2.355055e-01, 251,2.566416e-01, 252,2.459227e-01)
.param C7ESL=table(run, 1,1.000000e-09, 2,1.000000e-09, 3,9.717777e-10, 4,1.172561e-09, 5,1.134302e-09, 6,8.158180e-10, 7,8.568399e-10, 8,7.143146e-10,
+ 9,7.405106e-10, 10,7.766150e-10, 11,8.561836e-10, 12,1.129116e-09, 13,1.073851e-09, 14,6.070325e-10, 15,7.492353e-10, 16,1.052645e-09,
+ 17,8.951882e-10, 18,8.992607e-10, 19,6.522541e-10, 20,7.461455e-10, 21,1.013498e-09, 22,6.087885e-10, 23,9.090031e-10, 24,8.953411e-10,
+ 25,1.112061e-09, 26,9.701559e-10, 27,6.451816e-10, 28,1.023975e-09, 29,6.072852e-10, 30,1.075372e-09, 31,9.357689e-10, 32,7.029783e-10,
+ 33,7.138354e-10, 34,9.240817e-10, 35,1.006831e-09, 36,1.081742e-09, 37,9.305653e-10, 38,6.703792e-10, 39,1.058014e-09, 40,6.610196e-10,
+ 41,9.710641e-10, 42,9.165110e-10, 43,9.454669e-10, 44,1.017981e-09, 45,1.191754e-09, 46,7.602566e-10, 47,9.564270e-10, 48,7.911931e-10,
+ 49,7.075735e-10, 50,1.197980e-09, 51,6.404474e-10, 52,6.270391e-10, 53,7.044820e-10, 54,9.965311e-10, 55,7.927276e-10, 56,1.147149e-09,
+ 57,1.150310e-09, 58,9.844358e-10, 59,9.146695e-10, 60,9.216468e-10, 61,7.428225e-10, 62,1.052661e-09, 63,1.087161e-09, 64,8.409641e-10,
+ 65,1.064438e-09, 66,8.426941e-10, 67,7.805056e-10, 68,6.049201e-10, 69,1.022241e-09, 70,1.053449e-09, 71,8.460985e-10, 72,1.041928e-09,
+ 73,9.520758e-10, 74,7.017468e-10, 75,8.050666e-10, 76,9.726460e-10, 77,7.480195e-10, 78,6.752388e-10, 79,1.155405e-09, 80,1.032129e-09,
+ 81,8.891427e-10, 82,7.053881e-10, 83,1.160268e-09, 84,9.922061e-10, 85,9.309515e-10, 86,1.029295e-09, 87,8.447400e-10, 88,6.658574e-10,
+ 89,6.465585e-10, 90,1.049082e-09, 91,9.641255e-10, 92,1.056115e-09, 93,1.101189e-09, 94,6.536287e-10, 95,1.189191e-09, 96,1.046259e-09,
+ 97,8.308104e-10, 98,1.131100e-09, 99,1.152911e-09, 100,9.105583e-10, 101,6.631093e-10, 102,7.740271e-10, 103,6.042057e-10, 104,8.919610e-10,
+ 105,8.539306e-10, 106,8.617432e-10, 107,9.125935e-10, 108,1.057893e-09, 109,9.758992e-10, 110,6.568102e-10, 111,1.139429e-09, 112,1.056111e-09,
+ 113,1.064569e-09, 114,1.168326e-09, 115,8.707850e-10, 116,9.452436e-10, 117,9.074423e-10, 118,8.595320e-10, 119,8.534268e-10, 120,1.076769e-09,
+ 121,7.168449e-10, 122,9.512521e-10, 123,6.839909e-10, 124,8.260507e-10, 125,9.475035e-10, 126,6.222496e-10, 127,7.094917e-10, 128,1.011946e-09,
+ 129,1.104548e-09, 130,6.376255e-10, 131,1.148775e-09, 132,1.092482e-09, 133,7.281040e-10, 134,9.760028e-10, 135,9.928648e-10, 136,1.156262e-09,
+ 137,1.058182e-09, 138,1.180620e-09, 139,8.051004e-10, 140,6.074472e-10, 141,1.102424e-09, 142,7.486771e-10, 143,7.728688e-10, 144,8.528362e-10,
+ 145,1.006336e-09, 146,9.183875e-10, 147,1.061347e-09, 148,7.038727e-10, 149,9.558492e-10, 150,8.765832e-10, 151,8.947816e-10, 152,6.878903e-10,
+ 153,1.028483e-09, 154,9.265566e-10, 155,1.181951e-09, 156,9.963408e-10, 157,9.041276e-10, 158,7.484607e-10, 159,6.909948e-10, 160,9.382369e-10,
+ 161,6.752547e-10, 162,9.153233e-10, 163,1.061256e-09, 164,7.289233e-10, 165,1.061773e-09, 166,1.017085e-09, 167,9.199024e-10, 168,6.196165e-10,
+ 169,1.100159e-09, 170,8.334593e-10, 171,1.085881e-09, 172,7.154812e-10, 173,6.836945e-10, 174,1.001636e-09, 175,6.327997e-10, 176,8.379330e-10,
+ 177,1.131591e-09, 178,1.097341e-09, 179,6.082150e-10, 180,8.320536e-10, 181,7.098342e-10, 182,6.169905e-10, 183,9.933798e-10, 184,6.806860e-10,
+ 185,1.125062e-09, 186,9.344956e-10, 187,1.142957e-09, 188,7.715831e-10, 189,1.128107e-09, 190,1.057617e-09, 191,1.127825e-09, 192,7.701030e-10,
+ 193,1.130795e-09, 194,1.068326e-09, 195,6.581741e-10, 196,8.017188e-10, 197,1.045313e-09, 198,9.860843e-10, 199,1.104407e-09, 200,9.816907e-10,
+ 201,8.216691e-10, 202,7.421272e-10, 203,1.086500e-09, 204,9.138477e-10, 205,8.003657e-10, 206,8.806966e-10, 207,1.088697e-09, 208,6.500982e-10,
+ 209,1.173765e-09, 210,7.796285e-10, 211,6.132304e-10, 212,9.642574e-10, 213,6.312348e-10, 214,6.570907e-10, 215,7.216255e-10, 216,8.035781e-10,
+ 217,6.116730e-10, 218,7.932546e-10, 219,1.179818e-09, 220,7.973823e-10, 221,1.094903e-09, 222,6.833850e-10, 223,6.658111e-10, 224,1.111279e-09,
+ 225,1.116896e-09, 226,7.053472e-10, 227,1.114170e-09, 228,6.563853e-10, 229,1.137896e-09, 230,8.406405e-10, 231,9.061842e-10, 232,1.188203e-09,
+ 233,8.969021e-10, 234,1.104373e-09, 235,1.113740e-09, 236,9.865198e-10, 237,8.535833e-10, 238,1.166095e-09, 239,6.597820e-10, 240,7.113227e-10,
+ 241,1.027689e-09, 242,8.384884e-10, 243,6.544086e-10, 244,6.941481e-10, 245,7.958813e-10, 246,1.030948e-09, 247,7.517127e-10, 248,1.028728e-09,
+ 249,1.197003e-09, 250,6.205320e-10, 251,1.043607e-09, 252,8.723712e-10)
.param C7Lvia=table(run, 1,8.496433e-10, 2,8.496433e-10, 3,9.009408e-10, 4,5.405193e-10, 5,6.992537e-10, 6,8.881807e-10, 7,4.533180e-10, 8,9.593315e-10,
+ 9,5.546716e-10, 10,1.188784e-09, 11,8.821246e-10, 12,4.499551e-10, 13,7.567964e-10, 14,9.448081e-10, 15,5.747592e-10, 16,3.463081e-10,
+ 17,7.065007e-10, 18,8.134375e-10, 19,8.829671e-10, 20,9.183077e-10, 21,6.195407e-10, 22,3.828910e-10, 23,3.054073e-10, 24,9.225235e-10,
+ 25,5.022866e-10, 26,1.060512e-09, 27,6.516286e-10, 28,2.851599e-10, 29,7.791431e-10, 30,1.124542e-09, 31,1.103970e-09, 32,6.830390e-10,
+ 33,4.790586e-10, 34,6.005439e-10, 35,1.093667e-09, 36,1.014320e-09, 37,1.075003e-09, 38,1.234586e-09, 39,8.259743e-10, 40,8.782622e-10,
+ 41,5.522951e-10, 42,1.092937e-09, 43,6.412208e-10, 44,1.152027e-09, 45,8.521957e-10, 46,1.027407e-09, 47,3.784199e-10, 48,3.496357e-10,
+ 49,1.020918e-09, 50,1.292060e-09, 51,4.524025e-10, 52,3.442379e-10, 53,8.872707e-10, 54,6.251345e-10, 55,6.452230e-10, 56,1.026831e-09,
+ 57,4.927634e-10, 58,1.190001e-09, 59,9.601673e-10, 60,1.104175e-09, 61,1.294408e-09, 62,5.445836e-10, 63,9.361827e-10, 64,1.079687e-09,
+ 65,4.015993e-10, 66,9.540909e-10, 67,3.985382e-10, 68,3.242415e-10, 69,6.744471e-10, 70,1.298106e-09, 71,1.143350e-09, 72,8.687983e-10,
+ 73,7.176769e-10, 74,7.199852e-10, 75,1.224511e-09, 76,9.236762e-10, 77,2.823430e-10, 78,1.106981e-09, 79,9.418122e-10, 80,7.383404e-10,
+ 81,1.208500e-09, 82,8.292178e-10, 83,9.036736e-10, 84,1.158677e-09, 85,3.867804e-10, 86,4.758419e-10, 87,3.098213e-10, 88,6.025793e-10,
+ 89,9.548828e-10, 90,7.781191e-10, 91,4.835532e-10, 92,1.270356e-09, 93,5.867391e-10, 94,9.702913e-10, 95,9.124836e-10, 96,7.248744e-10,
+ 97,3.884062e-10, 98,8.746066e-10, 99,9.888247e-10, 100,9.791074e-10, 101,6.291919e-10, 102,1.165299e-09, 103,9.810210e-10, 104,4.011482e-10,
+ 105,7.168039e-10, 106,4.614327e-10, 107,8.841595e-10, 108,3.150891e-10, 109,8.654875e-10, 110,1.045814e-09, 111,1.000696e-09, 112,5.679792e-10,
+ 113,9.525150e-10, 114,6.726876e-10, 115,5.811068e-10, 116,7.240048e-10, 117,5.529222e-10, 118,4.212778e-10, 119,5.659735e-10, 120,1.275624e-09,
+ 121,9.934781e-10, 122,4.709816e-10, 123,1.032748e-09, 124,8.474846e-10, 125,1.255487e-09, 126,8.098252e-10, 127,3.320144e-10, 128,1.056423e-09,
+ 129,1.064872e-09, 130,1.279001e-09, 131,7.610800e-10, 132,6.213426e-10, 133,7.844128e-10, 134,1.150287e-09, 135,6.103045e-10, 136,7.360964e-10,
+ 137,1.074799e-09, 138,8.898539e-10, 139,4.407992e-10, 140,6.653224e-10, 141,9.369728e-10, 142,4.178610e-10, 143,8.709602e-10, 144,5.165076e-10,
+ 145,1.125057e-09, 146,4.472338e-10, 147,1.132424e-09, 148,8.890863e-10, 149,5.911941e-10, 150,2.828956e-10, 151,9.448276e-10, 152,6.003120e-10,
+ 153,7.658569e-10, 154,8.665349e-10, 155,4.459971e-10, 156,3.928275e-10, 157,3.524662e-10, 158,8.143709e-10, 159,5.903383e-10, 160,1.150384e-09,
+ 161,7.712269e-10, 162,4.232818e-10, 163,9.476144e-10, 164,9.420477e-10, 165,5.049940e-10, 166,2.792461e-10, 167,3.022246e-10, 168,8.443394e-10,
+ 169,9.934934e-10, 170,5.586418e-10, 171,7.654242e-10, 172,7.468327e-10, 173,3.024181e-10, 174,5.325613e-10, 175,4.927697e-10, 176,5.714896e-10,
+ 177,1.027163e-09, 178,9.536611e-10, 179,1.171704e-09, 180,8.278117e-10, 181,2.737437e-10, 182,1.068123e-09, 183,3.883118e-10, 184,3.650782e-10,
+ 185,1.152035e-09, 186,9.340737e-10, 187,9.208795e-10, 188,1.221796e-09, 189,1.103088e-09, 190,9.996873e-10, 191,8.976024e-10, 192,5.760051e-10,
+ 193,1.244670e-09, 194,4.697036e-10, 195,1.088697e-09, 196,1.069834e-09, 197,4.445145e-10, 198,6.670996e-10, 199,1.096487e-09, 200,6.788961e-10,
+ 201,4.519187e-10, 202,4.151585e-10, 203,7.254240e-10, 204,9.033287e-10, 205,1.214440e-09, 206,9.079627e-10, 207,2.901708e-10, 208,2.787300e-10,
+ 209,9.866287e-10, 210,1.127248e-09, 211,2.930894e-10, 212,8.279725e-10, 213,4.100326e-10, 214,1.062699e-09, 215,5.370669e-10, 216,1.010382e-09,
+ 217,6.359421e-10, 218,5.464445e-10, 219,3.926542e-10, 220,6.961256e-10, 221,9.821790e-10, 222,3.681214e-10, 223,8.849259e-10, 224,5.152850e-10,
+ 225,1.122422e-09, 226,4.005614e-10, 227,7.613380e-10, 228,6.598474e-10, 229,3.307348e-10, 230,4.218210e-10, 231,4.435655e-10, 232,1.240541e-09,
+ 233,4.450576e-10, 234,2.770941e-10, 235,5.584283e-10, 236,1.092016e-09, 237,1.023118e-09, 238,7.177846e-10, 239,1.081481e-09, 240,8.066210e-10,
+ 241,1.001963e-09, 242,2.921544e-10, 243,8.161703e-10, 244,9.612817e-10, 245,1.122729e-09, 246,9.856122e-10, 247,7.195176e-10, 248,8.924562e-10,
+ 249,1.069171e-09, 250,7.339590e-10, 251,7.439673e-10, 252,3.610394e-10)
.param C7Cpad=table(run, 1,3.489749e-13, 2,3.489749e-13, 3,5.133812e-13, 4,3.781133e-13, 5,4.461606e-13, 6,3.913342e-13, 7,4.734439e-13, 8,5.285184e-13,
+ 9,2.132654e-13, 10,2.871161e-13, 11,3.034468e-13, 12,3.050624e-13, 13,4.655292e-13, 14,4.195790e-13, 15,1.697657e-13, 16,2.082441e-13,
+ 17,2.936991e-13, 18,3.823754e-13, 19,3.358756e-13, 20,1.748823e-13, 21,3.692334e-13, 22,3.361280e-13, 23,4.649617e-13, 24,4.026869e-13,
+ 25,4.752344e-13, 26,2.885664e-13, 27,3.906626e-13, 28,2.341987e-13, 29,2.014791e-13, 30,2.581643e-13, 31,4.475689e-13, 32,1.971802e-13,
+ 33,3.513640e-13, 34,1.830486e-13, 35,3.684074e-13, 36,3.108558e-13, 37,4.197512e-13, 38,1.772913e-13, 39,5.143869e-13, 40,2.038569e-13,
+ 41,3.208503e-13, 42,3.615263e-13, 43,3.394170e-13, 44,2.193758e-13, 45,2.769947e-13, 46,4.825566e-13, 47,3.506693e-13, 48,3.055096e-13,
+ 49,2.783634e-13, 50,5.224993e-13, 51,4.508499e-13, 52,4.674080e-13, 53,3.823560e-13, 54,1.979994e-13, 55,2.025514e-13, 56,3.370218e-13,
+ 57,5.190262e-13, 58,2.624395e-13, 59,4.983289e-13, 60,2.377617e-13, 61,5.186349e-13, 62,4.639342e-13, 63,3.980687e-13, 64,1.919700e-13,
+ 65,3.756258e-13, 66,5.030375e-13, 67,3.417241e-13, 68,1.831029e-13, 69,1.918024e-13, 70,3.817270e-13, 71,2.174568e-13, 72,4.956531e-13,
+ 73,3.447040e-13, 74,2.277896e-13, 75,2.335870e-13, 76,3.306080e-13, 77,2.904688e-13, 78,2.852348e-13, 79,2.765333e-13, 80,4.386360e-13,
+ 81,3.977214e-13, 82,3.757752e-13, 83,2.280270e-13, 84,2.707044e-13, 85,5.252174e-13, 86,1.714428e-13, 87,5.258860e-13, 88,3.084162e-13,
+ 89,4.470110e-13, 90,2.694764e-13, 91,2.698748e-13, 92,1.999042e-13, 93,3.827875e-13, 94,4.749837e-13, 95,4.094516e-13, 96,2.070559e-13,
+ 97,4.952553e-13, 98,3.025138e-13, 99,4.844453e-13, 100,5.033951e-13, 101,3.583983e-13, 102,4.595222e-13, 103,4.911837e-13, 104,1.722827e-13,
+ 105,5.189920e-13, 106,4.856656e-13, 107,1.752846e-13, 108,2.602172e-13, 109,5.114440e-13, 110,2.124653e-13, 111,2.316346e-13, 112,3.904753e-13,
+ 113,2.017125e-13, 114,3.207470e-13, 115,2.511928e-13, 116,4.027440e-13, 117,4.523931e-13, 118,5.228282e-13, 119,4.014154e-13, 120,3.172198e-13,
+ 121,3.488297e-13, 122,3.212942e-13, 123,5.111445e-13, 124,5.181503e-13, 125,5.270438e-13, 126,5.011853e-13, 127,2.629559e-13, 128,4.339298e-13,
+ 129,3.937013e-13, 130,2.806041e-13, 131,3.667003e-13, 132,3.209270e-13, 133,4.030944e-13, 134,4.738360e-13, 135,2.602926e-13, 136,4.865336e-13,
+ 137,2.259293e-13, 138,4.930573e-13, 139,3.373196e-13, 140,4.993453e-13, 141,3.582579e-13, 142,1.847950e-13, 143,2.271215e-13, 144,4.784043e-13,
+ 145,3.806523e-13, 146,4.934979e-13, 147,4.760025e-13, 148,4.599336e-13, 149,4.583677e-13, 150,4.525232e-13, 151,3.192351e-13, 152,1.891715e-13,
+ 153,4.632483e-13, 154,3.378858e-13, 155,4.506585e-13, 156,1.835169e-13, 157,4.480518e-13, 158,1.702270e-13, 159,3.390651e-13, 160,4.804568e-13,
+ 161,2.581456e-13, 162,3.803982e-13, 163,3.537747e-13, 164,2.473466e-13, 165,3.620511e-13, 166,3.188638e-13, 167,4.260070e-13, 168,2.534850e-13,
+ 169,3.382755e-13, 170,2.693228e-13, 171,2.440792e-13, 172,4.860417e-13, 173,4.060561e-13, 174,5.016166e-13, 175,4.625386e-13, 176,3.778067e-13,
+ 177,3.167733e-13, 178,4.548185e-13, 179,3.276789e-13, 180,1.724048e-13, 181,3.364212e-13, 182,2.279554e-13, 183,2.299813e-13, 184,3.781645e-13,
+ 185,2.944863e-13, 186,3.364136e-13, 187,3.279204e-13, 188,4.862495e-13, 189,4.086662e-13, 190,2.461283e-13, 191,2.922334e-13, 192,2.952089e-13,
+ 193,4.804298e-13, 194,4.841755e-13, 195,4.678004e-13, 196,4.899368e-13, 197,2.340064e-13, 198,3.343062e-13, 199,3.764045e-13, 200,4.070473e-13,
+ 201,2.316592e-13, 202,5.029362e-13, 203,1.986018e-13, 204,1.692270e-13, 205,3.547287e-13, 206,4.505619e-13, 207,4.794491e-13, 208,2.283688e-13,
+ 209,4.097304e-13, 210,2.294972e-13, 211,3.457192e-13, 212,4.163353e-13, 213,3.840702e-13, 214,5.069350e-13, 215,2.058400e-13, 216,4.086486e-13,
+ 217,2.232916e-13, 218,3.632238e-13, 219,4.183689e-13, 220,3.248942e-13, 221,3.577345e-13, 222,4.799306e-13, 223,3.830087e-13, 224,4.618793e-13,
+ 225,4.140538e-13, 226,2.510701e-13, 227,5.128051e-13, 228,2.602681e-13, 229,5.062694e-13, 230,5.102925e-13, 231,3.167559e-13, 232,4.310945e-13,
+ 233,4.303633e-13, 234,2.143764e-13, 235,1.915860e-13, 236,5.109332e-13, 237,4.755075e-13, 238,4.321004e-13, 239,5.150148e-13, 240,1.780033e-13,
+ 241,2.339646e-13, 242,4.083332e-13, 243,2.190452e-13, 244,2.250487e-13, 245,3.561601e-13, 246,2.794365e-13, 247,2.753875e-13, 248,5.215244e-13,
+ 249,3.686135e-13, 250,2.424092e-13, 251,4.353848e-13, 252,4.491087e-13)
.param L2L=table(run, 1,6.596000e-08, 2,7.004000e-08, 3,6.988608e-08, 4,6.643743e-08, 5,6.743941e-08, 6,6.755124e-08, 7,6.815011e-08, 8,6.623735e-08,
+ 9,6.681162e-08, 10,7.000965e-08, 11,6.608219e-08, 12,6.817186e-08, 13,6.750076e-08, 14,6.815878e-08, 15,6.700848e-08, 16,6.703519e-08,
+ 17,6.648675e-08, 18,6.779267e-08, 19,6.823768e-08, 20,6.855233e-08, 21,6.851873e-08, 22,6.640904e-08, 23,6.992490e-08, 24,6.818787e-08,
+ 25,6.614753e-08, 26,6.881254e-08, 27,6.996280e-08, 28,6.806660e-08, 29,6.961405e-08, 30,6.757427e-08, 31,6.972709e-08, 32,6.782901e-08,
+ 33,6.703805e-08, 34,6.681937e-08, 35,6.696383e-08, 36,6.922700e-08, 37,6.944320e-08, 38,6.823494e-08, 39,6.761146e-08, 40,6.844814e-08,
+ 41,6.641604e-08, 42,6.735654e-08, 43,6.631446e-08, 44,6.995721e-08, 45,6.891526e-08, 46,6.741359e-08, 47,6.883154e-08, 48,6.684243e-08,
+ 49,6.863962e-08, 50,6.802777e-08, 51,6.638959e-08, 52,6.739628e-08, 53,6.745448e-08, 54,6.700941e-08, 55,6.842204e-08, 56,6.654495e-08,
+ 57,6.694622e-08, 58,6.922857e-08, 59,6.982781e-08, 60,6.743826e-08, 61,6.907180e-08, 62,6.849549e-08, 63,6.679919e-08, 64,6.608602e-08,
+ 65,6.727662e-08, 66,6.746364e-08, 67,6.655311e-08, 68,6.732852e-08, 69,6.608505e-08, 70,6.711995e-08, 71,6.932964e-08, 72,6.956641e-08,
+ 73,6.670145e-08, 74,6.813363e-08, 75,6.625291e-08, 76,6.891666e-08, 77,6.596640e-08, 78,6.617691e-08, 79,6.599330e-08, 80,6.903598e-08,
+ 81,6.901157e-08, 82,6.799860e-08, 83,6.998670e-08, 84,6.862009e-08, 85,6.874614e-08, 86,6.710619e-08, 87,6.697842e-08, 88,6.732081e-08,
+ 89,6.846456e-08, 90,6.759804e-08, 91,6.777086e-08, 92,6.609134e-08, 93,6.630433e-08, 94,6.709376e-08, 95,6.952273e-08, 96,6.771321e-08,
+ 97,6.773901e-08, 98,6.859507e-08, 99,6.800941e-08, 100,6.995465e-08, 101,6.701622e-08, 102,6.937215e-08, 103,6.955433e-08, 104,6.882546e-08,
+ 105,6.797863e-08, 106,6.736179e-08, 107,6.890118e-08, 108,6.804398e-08, 109,6.998502e-08, 110,6.608982e-08, 111,6.803533e-08, 112,6.836805e-08,
+ 113,6.823409e-08, 114,6.750641e-08, 115,6.757626e-08, 116,6.810690e-08, 117,6.881958e-08, 118,6.865935e-08, 119,6.924307e-08, 120,6.939281e-08,
+ 121,6.667797e-08, 122,6.951373e-08, 123,6.984600e-08, 124,6.693109e-08, 125,6.943413e-08, 126,6.861299e-08, 127,6.790121e-08, 128,6.758501e-08,
+ 129,6.610398e-08, 130,6.750695e-08, 131,6.803218e-08, 132,6.905440e-08, 133,6.635708e-08, 134,6.893772e-08, 135,6.864825e-08, 136,6.709935e-08,
+ 137,6.897841e-08, 138,6.764896e-08, 139,6.750161e-08, 140,6.700373e-08, 141,6.604157e-08, 142,6.722848e-08, 143,6.754621e-08, 144,6.713166e-08,
+ 145,6.949407e-08, 146,6.614352e-08, 147,6.802064e-08, 148,6.615872e-08, 149,6.899832e-08, 150,6.804688e-08, 151,6.882056e-08, 152,6.919067e-08,
+ 153,6.847705e-08, 154,6.923994e-08, 155,6.806909e-08, 156,6.614799e-08, 157,6.677778e-08, 158,6.902066e-08, 159,6.698240e-08, 160,6.718570e-08,
+ 161,6.738145e-08, 162,6.661126e-08, 163,7.001646e-08, 164,6.745459e-08, 165,6.651397e-08, 166,6.718071e-08, 167,6.803741e-08, 168,6.812803e-08,
+ 169,6.601926e-08, 170,6.769019e-08, 171,6.985005e-08, 172,6.613556e-08, 173,6.716869e-08, 174,6.994312e-08, 175,6.664404e-08, 176,6.694556e-08,
+ 177,6.715814e-08, 178,6.978527e-08, 179,6.984671e-08, 180,6.870465e-08, 181,6.968716e-08, 182,6.737914e-08, 183,6.743432e-08, 184,6.636100e-08,
+ 185,6.963247e-08, 186,6.973212e-08, 187,6.781678e-08, 188,6.900046e-08, 189,6.898009e-08, 190,6.826657e-08, 191,6.962035e-08, 192,6.652126e-08,
+ 193,6.810003e-08, 194,6.680158e-08, 195,6.670290e-08, 196,6.679376e-08, 197,6.713984e-08, 198,6.902433e-08, 199,6.648101e-08, 200,6.949796e-08,
+ 201,6.931450e-08, 202,6.664570e-08, 203,6.993627e-08, 204,6.866498e-08, 205,6.706320e-08, 206,6.944970e-08, 207,6.788474e-08, 208,6.915921e-08,
+ 209,6.954777e-08, 210,6.641565e-08, 211,6.717221e-08, 212,6.882330e-08, 213,6.795592e-08, 214,6.861291e-08, 215,6.789947e-08, 216,6.894961e-08,
+ 217,6.700280e-08, 218,6.903326e-08, 219,6.983770e-08, 220,6.751582e-08, 221,6.713100e-08, 222,6.900748e-08, 223,6.897382e-08, 224,6.936772e-08,
+ 225,6.651101e-08, 226,6.729277e-08, 227,6.803875e-08, 228,6.798063e-08, 229,6.878569e-08, 230,6.767919e-08, 231,6.789465e-08, 232,6.987007e-08,
+ 233,6.882722e-08, 234,6.840168e-08, 235,6.715261e-08, 236,6.740168e-08, 237,6.970409e-08, 238,6.914076e-08, 239,6.856078e-08, 240,6.722781e-08,
+ 241,6.835354e-08, 242,6.888729e-08, 243,6.998330e-08, 244,6.993443e-08, 245,6.937365e-08, 246,6.949156e-08, 247,6.925156e-08, 248,6.804067e-08,
+ 249,6.939325e-08, 250,6.723364e-08, 251,6.926885e-08, 252,6.901314e-08)
.param L2R=table(run, 1,3.488362e-01, 2,3.704136e-01, 3,4.589867e-01, 4,3.901881e-01, 5,2.866043e-01, 6,3.590625e-01, 7,4.396850e-01, 8,3.359119e-01,
+ 9,3.295957e-01, 10,2.967319e-01, 11,4.188323e-01, 12,3.492722e-01, 13,3.643658e-01, 14,4.631699e-01, 15,4.669708e-01, 16,3.102139e-01,
+ 17,3.949713e-01, 18,3.079150e-01, 19,2.927113e-01, 20,4.263402e-01, 21,3.395010e-01, 22,4.162937e-01, 23,4.528488e-01, 24,3.094507e-01,
+ 25,3.244446e-01, 26,3.121677e-01, 27,4.598720e-01, 28,3.171140e-01, 29,3.478643e-01, 30,3.077407e-01, 31,3.206375e-01, 32,2.979055e-01,
+ 33,4.056744e-01, 34,3.732489e-01, 35,3.303948e-01, 36,3.952429e-01, 37,3.825383e-01, 38,3.261018e-01, 39,3.199649e-01, 40,4.490495e-01,
+ 41,4.669908e-01, 42,3.743640e-01, 43,3.001834e-01, 44,3.476692e-01, 45,4.164350e-01, 46,3.029112e-01, 47,2.923462e-01, 48,3.904161e-01,
+ 49,3.778480e-01, 50,4.127650e-01, 51,3.056698e-01, 52,3.599745e-01, 53,3.158180e-01, 54,3.933870e-01, 55,2.945890e-01, 56,4.060997e-01,
+ 57,4.686228e-01, 58,3.752705e-01, 59,3.978770e-01, 60,4.441513e-01, 61,3.431194e-01, 62,3.117681e-01, 63,3.722612e-01, 64,3.966237e-01,
+ 65,3.712528e-01, 66,4.518735e-01, 67,4.096169e-01, 68,4.277292e-01, 69,3.051652e-01, 70,3.159315e-01, 71,4.155023e-01, 72,4.814400e-01,
+ 73,3.245350e-01, 74,3.876702e-01, 75,3.057275e-01, 76,4.296943e-01, 77,4.175775e-01, 78,3.915312e-01, 79,3.288618e-01, 80,4.334289e-01,
+ 81,4.318536e-01, 82,4.280056e-01, 83,4.130107e-01, 84,4.539212e-01, 85,3.079885e-01, 86,3.168063e-01, 87,4.630942e-01, 88,4.326316e-01,
+ 89,4.426179e-01, 90,3.203930e-01, 91,4.337242e-01, 92,4.555822e-01, 93,3.631436e-01, 94,3.864007e-01, 95,3.953328e-01, 96,3.421459e-01,
+ 97,3.053364e-01, 98,3.613538e-01, 99,2.968981e-01, 100,3.794205e-01, 101,3.295462e-01, 102,3.573612e-01, 103,4.743953e-01, 104,4.021941e-01,
+ 105,3.872901e-01, 106,3.142828e-01, 107,3.170282e-01, 108,4.364697e-01, 109,3.321227e-01, 110,3.494754e-01, 111,2.950938e-01, 112,3.611699e-01,
+ 113,2.960401e-01, 114,3.357100e-01, 115,4.469895e-01, 116,4.650014e-01, 117,4.353059e-01, 118,3.684401e-01, 119,4.091404e-01, 120,4.564054e-01,
+ 121,4.691205e-01, 122,4.361277e-01, 123,3.972819e-01, 124,4.520769e-01, 125,3.809462e-01, 126,3.760081e-01, 127,3.999275e-01, 128,3.089542e-01,
+ 129,4.424720e-01, 130,3.068142e-01, 131,4.004663e-01, 132,4.136793e-01, 133,2.932604e-01, 134,4.284814e-01, 135,2.975122e-01, 136,4.516158e-01,
+ 137,3.085837e-01, 138,4.400368e-01, 139,4.229813e-01, 140,4.495241e-01, 141,4.191633e-01, 142,2.939417e-01, 143,4.071684e-01, 144,2.841659e-01,
+ 145,3.206440e-01, 146,4.007693e-01, 147,2.977962e-01, 148,4.049569e-01, 149,4.011465e-01, 150,4.108436e-01, 151,3.181034e-01, 152,4.468776e-01,
+ 153,3.122207e-01, 154,3.090288e-01, 155,2.929614e-01, 156,4.620584e-01, 157,3.104857e-01, 158,2.997927e-01, 159,3.521252e-01, 160,3.754180e-01,
+ 161,4.743465e-01, 162,3.269850e-01, 163,3.111886e-01, 164,3.712657e-01, 165,4.517458e-01, 166,3.996916e-01, 167,3.459342e-01, 168,3.179164e-01,
+ 169,3.007634e-01, 170,2.945315e-01, 171,3.988003e-01, 172,3.639587e-01, 173,4.445933e-01, 174,4.899806e-01, 175,4.593625e-01, 176,3.480981e-01,
+ 177,3.738995e-01, 178,3.965216e-01, 179,4.537606e-01, 180,3.216059e-01, 181,3.102874e-01, 182,3.664113e-01, 183,2.857644e-01, 184,3.229385e-01,
+ 185,3.514582e-01, 186,4.575594e-01, 187,3.055595e-01, 188,4.817158e-01, 189,3.792071e-01, 190,4.310292e-01, 191,3.597085e-01, 192,3.828950e-01,
+ 193,4.434798e-01, 194,3.269060e-01, 195,4.583896e-01, 196,2.898855e-01, 197,3.907153e-01, 198,2.957528e-01, 199,3.903290e-01, 200,3.984642e-01,
+ 201,2.943899e-01, 202,3.014707e-01, 203,3.757536e-01, 204,4.399265e-01, 205,3.180094e-01, 206,3.653334e-01, 207,3.097004e-01, 208,3.813894e-01,
+ 209,4.466309e-01, 210,3.837734e-01, 211,3.233651e-01, 212,3.130966e-01, 213,3.486381e-01, 214,4.601740e-01, 215,4.417956e-01, 216,4.034797e-01,
+ 217,2.981873e-01, 218,3.169889e-01, 219,3.830684e-01, 220,3.773767e-01, 221,3.279157e-01, 222,3.900072e-01, 223,3.682854e-01, 224,4.058759e-01,
+ 225,3.151826e-01, 226,3.608353e-01, 227,4.742247e-01, 228,2.976208e-01, 229,3.247974e-01, 230,3.600555e-01, 231,4.295269e-01, 232,4.060692e-01,
+ 233,4.303734e-01, 234,3.134976e-01, 235,2.879355e-01, 236,3.481871e-01, 237,4.821678e-01, 238,4.097158e-01, 239,3.102950e-01, 240,4.272155e-01,
+ 241,3.153410e-01, 242,2.954565e-01, 243,3.191051e-01, 244,4.559853e-01, 245,3.015259e-01, 246,3.073754e-01, 247,3.809297e-01, 248,3.015101e-01,
+ 249,4.744860e-01, 250,2.989541e-01, 251,4.882871e-01, 252,4.193558e-01)
.param L2C=table(run, 1,2.296805e-13, 2,2.192136e-13, 3,1.688997e-13, 4,1.481762e-13, 5,2.018657e-13, 6,3.042002e-13, 7,2.407674e-13, 8,1.681697e-13,
+ 9,1.512862e-13, 10,2.639151e-13, 11,1.828341e-13, 12,2.738582e-13, 13,2.065593e-13, 14,1.369108e-13, 15,1.925772e-13, 16,2.798202e-13,
+ 17,2.600107e-13, 18,2.024378e-13, 19,1.931162e-13, 20,2.760028e-13, 21,1.762485e-13, 22,2.031596e-13, 23,1.198145e-13, 24,2.718418e-13,
+ 25,2.500670e-13, 26,2.425205e-13, 27,1.906913e-13, 28,2.819445e-13, 29,1.206320e-13, 30,2.346895e-13, 31,1.668196e-13, 32,2.236335e-13,
+ 33,1.766712e-13, 34,1.599009e-13, 35,1.924765e-13, 36,2.391076e-13, 37,1.217950e-13, 38,1.925585e-13, 39,1.811654e-13, 40,2.461943e-13,
+ 41,1.743129e-13, 42,3.123095e-13, 43,2.410370e-13, 44,1.810490e-13, 45,2.360927e-13, 46,1.515135e-13, 47,2.539770e-13, 48,1.993052e-13,
+ 49,2.479822e-13, 50,2.075136e-13, 51,2.107267e-13, 52,1.849477e-13, 53,1.955859e-13, 54,1.399733e-13, 55,1.874227e-13, 56,2.157033e-13,
+ 57,2.987751e-13, 58,1.833565e-13, 59,1.366932e-13, 60,1.677448e-13, 61,2.694406e-13, 62,1.989596e-13, 63,1.695447e-13, 64,3.130191e-13,
+ 65,1.774874e-13, 66,2.868969e-13, 67,1.523185e-13, 68,2.561527e-13, 69,1.895982e-13, 70,2.533391e-13, 71,2.011225e-13, 72,1.649584e-13,
+ 73,2.339610e-13, 74,1.315775e-13, 75,1.871613e-13, 76,1.980520e-13, 77,3.153784e-13, 78,1.717899e-13, 79,1.936855e-13, 80,1.437012e-13,
+ 81,2.201310e-13, 82,1.808945e-13, 83,2.086063e-13, 84,3.117488e-13, 85,1.312634e-13, 86,1.664441e-13, 87,2.232242e-13, 88,2.761397e-13,
+ 89,1.696022e-13, 90,1.962108e-13, 91,1.861320e-13, 92,1.900828e-13, 93,2.837527e-13, 94,1.654346e-13, 95,2.568284e-13, 96,2.522479e-13,
+ 97,2.003998e-13, 98,2.404084e-13, 99,1.735123e-13, 100,1.925263e-13, 101,2.689199e-13, 102,2.056253e-13, 103,1.881131e-13, 104,2.486172e-13,
+ 105,1.737176e-13, 106,2.232776e-13, 107,1.909897e-13, 108,1.962784e-13, 109,1.472189e-13, 110,1.438214e-13, 111,2.495467e-13, 112,2.520042e-13,
+ 113,1.231200e-13, 114,2.333365e-13, 115,1.230421e-13, 116,2.090776e-13, 117,1.661469e-13, 118,2.362133e-13, 119,2.578464e-13, 120,1.115942e-13,
+ 121,1.594386e-13, 122,1.406809e-13, 123,1.579913e-13, 124,1.578735e-13, 125,2.330422e-13, 126,2.690512e-13, 127,2.018219e-13, 128,1.646633e-13,
+ 129,2.493294e-13, 130,1.671721e-13, 131,3.165826e-13, 132,1.908804e-13, 133,2.795112e-13, 134,1.476076e-13, 135,1.596143e-13, 136,1.915769e-13,
+ 137,2.895424e-13, 138,2.062534e-13, 139,1.744765e-13, 140,2.117277e-13, 141,1.629400e-13, 142,1.967885e-13, 143,1.504245e-13, 144,1.385577e-13,
+ 145,2.829846e-13, 146,2.557935e-13, 147,1.729765e-13, 148,2.444271e-13, 149,1.683907e-13, 150,1.840823e-13, 151,1.904522e-13, 152,1.754383e-13,
+ 153,1.381979e-13, 154,1.656554e-13, 155,1.619071e-13, 156,1.540172e-13, 157,2.147802e-13, 158,1.643670e-13, 159,3.399557e-13, 160,1.600073e-13,
+ 161,1.465199e-13, 162,2.167196e-13, 163,1.709190e-13, 164,2.730307e-13, 165,1.681220e-13, 166,1.698467e-13, 167,2.984166e-13, 168,1.829130e-13,
+ 169,1.544316e-13, 170,1.463201e-13, 171,1.382055e-13, 172,2.550957e-13, 173,2.489003e-13, 174,2.195052e-13, 175,1.152845e-13, 176,2.937611e-13,
+ 177,1.858295e-13, 178,2.760787e-13, 179,1.534968e-13, 180,1.991989e-13, 181,2.079801e-13, 182,2.224157e-13, 183,1.846686e-13, 184,3.342247e-13,
+ 185,1.410530e-13, 186,1.671172e-13, 187,1.888104e-13, 188,1.761771e-13, 189,2.530080e-13, 190,1.901651e-13, 191,1.523203e-13, 192,1.504773e-13,
+ 193,2.486940e-13, 194,2.230406e-13, 195,1.570035e-13, 196,1.784014e-13, 197,1.244476e-13, 198,1.650457e-13, 199,2.054868e-13, 200,2.799213e-13,
+ 201,1.943319e-13, 202,2.935011e-13, 203,1.553972e-13, 204,2.224501e-13, 205,2.005871e-13, 206,2.761280e-13, 207,1.276048e-13, 208,1.745319e-13,
+ 209,2.171190e-13, 210,1.760236e-13, 211,1.953085e-13, 212,1.734613e-13, 213,2.093632e-13, 214,1.963714e-13, 215,1.775383e-13, 216,1.439396e-13,
+ 217,1.237905e-13, 218,2.722960e-13, 219,1.685828e-13, 220,2.366883e-13, 221,1.258554e-13, 222,1.474305e-13, 223,2.354908e-13, 224,1.246848e-13,
+ 225,1.953569e-13, 226,1.970468e-13, 227,2.193336e-13, 228,2.182706e-13, 229,1.250484e-13, 230,1.598617e-13, 231,1.544986e-13, 232,1.530693e-13,
+ 233,3.018310e-13, 234,1.300919e-13, 235,1.486875e-13, 236,1.815734e-13, 237,1.666460e-13, 238,2.452721e-13, 239,1.474208e-13, 240,2.827578e-13,
+ 241,3.009543e-13, 242,3.086375e-13, 243,1.477397e-13, 244,1.411957e-13, 245,1.874044e-13, 246,3.310648e-13, 247,1.253052e-13, 248,1.598889e-13,
+ 249,1.395384e-13, 250,1.644918e-13, 251,1.721558e-13, 252,1.509543e-13)
.param L2Ltr=table(run, 1,1.000000e-09, 2,1.000000e-09, 3,1.360269e-09, 4,6.960116e-10, 5,1.618858e-09, 6,1.844926e-09, 7,1.785416e-09, 8,1.750026e-09,
+ 9,5.914135e-10, 10,1.933385e-09, 11,6.167593e-10, 12,1.498855e-09, 13,9.422871e-10, 14,1.412465e-09, 15,7.700406e-10, 16,9.176530e-10,
+ 17,9.606005e-10, 18,1.284982e-09, 19,1.225923e-09, 20,1.597990e-09, 21,1.814771e-09, 22,1.041375e-09, 23,1.837718e-09, 24,1.867260e-09,
+ 25,1.743323e-09, 26,1.749550e-09, 27,1.631372e-09, 28,8.094200e-10, 29,1.267137e-09, 30,1.054361e-09, 31,9.992634e-10, 32,5.450252e-10,
+ 33,1.005778e-09, 34,1.570093e-09, 35,7.659267e-10, 36,1.312153e-09, 37,1.822091e-09, 38,1.492165e-09, 39,1.053122e-09, 40,1.583959e-09,
+ 41,7.714151e-10, 42,1.235510e-09, 43,9.941199e-10, 44,1.886937e-09, 45,1.896505e-09, 46,5.547004e-10, 47,1.541045e-09, 48,1.383502e-09,
+ 49,1.176390e-09, 50,1.527710e-09, 51,1.395236e-09, 52,8.745743e-10, 53,1.373553e-09, 54,1.928104e-09, 55,1.756264e-09, 56,9.908941e-10,
+ 57,1.728582e-09, 58,6.794318e-10, 59,8.936740e-10, 60,9.810751e-10, 61,8.452153e-10, 62,1.679636e-09, 63,9.272577e-10, 64,1.695533e-09,
+ 65,8.482658e-10, 66,1.683134e-09, 67,7.007169e-10, 68,1.288931e-09, 69,6.570488e-10, 70,9.674487e-10, 71,1.223576e-09, 72,1.974094e-09,
+ 73,1.435206e-09, 74,1.766741e-09, 75,1.893085e-09, 76,1.905492e-09, 77,5.645677e-10, 78,1.102564e-09, 79,1.313158e-09, 80,1.565262e-09,
+ 81,1.709505e-09, 82,1.732557e-09, 83,1.714850e-09, 84,1.789432e-09, 85,8.620681e-10, 86,1.619174e-09, 87,1.674696e-09, 88,1.814955e-09,
+ 89,1.815649e-09, 90,1.800828e-09, 91,1.664524e-09, 92,8.518892e-10, 93,7.494076e-10, 94,1.660200e-09, 95,1.835690e-09, 96,1.124288e-09,
+ 97,9.548394e-10, 98,9.783441e-10, 99,1.026030e-09, 100,5.834531e-10, 101,1.385557e-09, 102,1.835319e-09, 103,9.841137e-10, 104,1.222618e-09,
+ 105,6.380956e-10, 106,1.118461e-09, 107,1.318776e-09, 108,1.990654e-09, 109,1.447483e-09, 110,6.436788e-10, 111,8.041291e-10, 112,6.623847e-10,
+ 113,1.031021e-09, 114,5.438160e-10, 115,8.982896e-10, 116,1.933198e-09, 117,1.499859e-09, 118,1.322007e-09, 119,6.799631e-10, 120,5.308381e-10,
+ 121,1.799043e-09, 122,6.432460e-10, 123,1.840617e-09, 124,1.861644e-09, 125,1.272577e-09, 126,1.413664e-09, 127,5.441355e-10, 128,1.095246e-09,
+ 129,7.706518e-10, 130,1.999359e-09, 131,1.598450e-09, 132,1.071341e-09, 133,1.373075e-09, 134,8.679566e-10, 135,1.635032e-09, 136,7.841942e-10,
+ 137,8.700909e-10, 138,6.565716e-10, 139,1.829764e-09, 140,8.228224e-10, 141,1.969132e-09, 142,8.027422e-10, 143,5.689939e-10, 144,1.997401e-09,
+ 145,1.541594e-09, 146,5.485925e-10, 147,6.369697e-10, 148,9.734575e-10, 149,1.720419e-09, 150,8.363848e-10, 151,1.612627e-09, 152,6.552847e-10,
+ 153,7.060137e-10, 154,1.508368e-09, 155,1.340686e-09, 156,1.441897e-09, 157,7.897362e-10, 158,1.706236e-09, 159,1.512611e-09, 160,1.247692e-09,
+ 161,8.885693e-10, 162,1.963400e-09, 163,6.582743e-10, 164,1.779631e-09, 165,1.044698e-09, 166,1.693318e-09, 167,8.664712e-10, 168,1.497291e-09,
+ 169,1.217039e-09, 170,1.472653e-09, 171,1.538923e-09, 172,6.125941e-10, 173,7.512109e-10, 174,1.700557e-09, 175,9.959694e-10, 176,1.052973e-09,
+ 177,1.994957e-09, 178,1.033771e-09, 179,1.577457e-09, 180,1.229574e-09, 181,1.189400e-09, 182,1.688630e-09, 183,1.476002e-09, 184,6.075287e-10,
+ 185,6.658311e-10, 186,1.427023e-09, 187,1.252265e-09, 188,8.252317e-10, 189,8.027640e-10, 190,1.450079e-09, 191,8.609257e-10, 192,1.735877e-09,
+ 193,1.122605e-09, 194,1.374027e-09, 195,1.192615e-09, 196,1.116449e-09, 197,1.613909e-09, 198,5.601602e-10, 199,1.191592e-09, 200,1.971505e-09,
+ 201,5.503840e-10, 202,1.211202e-09, 203,8.660846e-10, 204,9.436088e-10, 205,1.226085e-09, 206,1.837064e-09, 207,5.022052e-10, 208,1.138198e-09,
+ 209,7.756153e-10, 210,1.839593e-09, 211,9.204517e-10, 212,7.218413e-10, 213,1.917372e-09, 214,1.133579e-09, 215,1.515390e-09, 216,1.420531e-09,
+ 217,1.247157e-09, 218,7.865171e-10, 219,1.665291e-09, 220,7.929849e-10, 221,5.554513e-10, 222,1.851842e-09, 223,1.845895e-09, 224,9.747567e-10,
+ 225,1.475134e-09, 226,1.497603e-09, 227,1.322553e-09, 228,7.453134e-10, 229,1.893443e-09, 230,8.646319e-10, 231,8.106249e-10, 232,1.792191e-09,
+ 233,1.095896e-09, 234,1.531396e-09, 235,1.841415e-09, 236,9.065073e-10, 237,1.583853e-09, 238,1.044148e-09, 239,1.053120e-09, 240,1.051978e-09,
+ 241,1.314965e-09, 242,5.826914e-10, 243,1.080407e-09, 244,7.244234e-10, 245,1.811326e-09, 246,1.469696e-09, 247,1.585423e-09, 248,1.242331e-09,
+ 249,8.720804e-10, 250,1.963287e-09, 251,1.821843e-09, 252,9.688760e-10)
.param L4L=table(run, 1,7.954000e-08, 2,8.446000e-08, 3,8.038400e-08, 4,8.362529e-08, 5,8.155718e-08, 6,8.221771e-08, 7,8.026180e-08, 8,8.387810e-08,
+ 9,7.990386e-08, 10,8.420030e-08, 11,8.212133e-08, 12,8.301756e-08, 13,8.058479e-08, 14,8.128420e-08, 15,8.044756e-08, 16,8.445272e-08,
+ 17,8.096466e-08, 18,8.104462e-08, 19,8.083767e-08, 20,7.999760e-08, 21,8.237932e-08, 22,8.058466e-08, 23,8.409677e-08, 24,7.971815e-08,
+ 25,8.190432e-08, 26,8.209435e-08, 27,8.093870e-08, 28,8.191048e-08, 29,8.195885e-08, 30,8.230949e-08, 31,8.417624e-08, 32,8.015217e-08,
+ 33,8.077625e-08, 34,8.113251e-08, 35,8.358947e-08, 36,8.235623e-08, 37,8.387354e-08, 38,8.408396e-08, 39,8.131634e-08, 40,8.111163e-08,
+ 41,8.122319e-08, 42,8.255972e-08, 43,8.190562e-08, 44,8.040495e-08, 45,8.168810e-08, 46,8.435168e-08, 47,8.101090e-08, 48,8.043217e-08,
+ 49,8.008473e-08, 50,8.170739e-08, 51,8.123800e-08, 52,8.344249e-08, 53,8.345816e-08, 54,8.152410e-08, 55,8.152430e-08, 56,8.437457e-08,
+ 57,8.058854e-08, 58,8.186142e-08, 59,8.401773e-08, 60,8.331919e-08, 61,8.115438e-08, 62,8.388832e-08, 63,8.333338e-08, 64,8.324834e-08,
+ 65,8.115501e-08, 66,8.436149e-08, 67,8.377469e-08, 68,8.033464e-08, 69,8.375632e-08, 70,8.256361e-08, 71,8.366588e-08, 72,8.084020e-08,
+ 73,8.202822e-08, 74,8.069534e-08, 75,8.220677e-08, 76,7.960896e-08, 77,7.962503e-08, 78,8.083730e-08, 79,8.275936e-08, 80,8.021236e-08,
+ 81,8.155814e-08, 82,8.297603e-08, 83,8.192180e-08, 84,8.228112e-08, 85,8.160245e-08, 86,8.336619e-08, 87,8.377216e-08, 88,8.406641e-08,
+ 89,8.406843e-08, 90,8.373411e-08, 91,8.232066e-08, 92,8.318798e-08, 93,8.045189e-08, 94,8.375856e-08, 95,8.239298e-08, 96,8.158717e-08,
+ 97,8.334014e-08, 98,8.133672e-08, 99,8.214502e-08, 100,8.026320e-08, 101,7.957927e-08, 102,8.164934e-08, 103,8.187679e-08, 104,8.268243e-08,
+ 105,7.972551e-08, 106,8.419141e-08, 107,8.181362e-08, 108,8.308851e-08, 109,8.357790e-08, 110,8.420920e-08, 111,8.025381e-08, 112,8.162329e-08,
+ 113,8.393460e-08, 114,7.966472e-08, 115,8.366847e-08, 116,8.196598e-08, 117,7.974960e-08, 118,8.139368e-08, 119,8.291050e-08, 120,8.248032e-08,
+ 121,8.388206e-08, 122,8.026029e-08, 123,7.972811e-08, 124,8.070544e-08, 125,8.007067e-08, 126,8.409037e-08, 127,8.282683e-08, 128,8.380295e-08,
+ 129,8.129728e-08, 130,8.021283e-08, 131,8.288295e-08, 132,8.436223e-08, 133,8.138967e-08, 134,8.198417e-08, 135,8.121771e-08, 136,8.355730e-08,
+ 137,8.158109e-08, 138,8.284692e-08, 139,8.183493e-08, 140,8.322419e-08, 141,8.363782e-08, 142,8.200612e-08, 143,8.413173e-08, 144,8.425502e-08,
+ 145,7.963791e-08, 146,8.004640e-08, 147,8.031472e-08, 148,8.190926e-08, 149,8.164765e-08, 150,8.306038e-08, 151,8.089791e-08, 152,8.412782e-08,
+ 153,8.312389e-08, 154,8.331797e-08, 155,8.164275e-08, 156,8.322458e-08, 157,8.250669e-08, 158,8.069798e-08, 159,8.300641e-08, 160,8.328360e-08,
+ 161,8.254677e-08, 162,8.014197e-08, 163,8.192286e-08, 164,8.342680e-08, 165,8.350681e-08, 166,8.248934e-08, 167,8.405175e-08, 168,8.094761e-08,
+ 169,8.183287e-08, 170,8.023468e-08, 171,8.167954e-08, 172,8.055253e-08, 173,8.031407e-08, 174,8.414159e-08, 175,8.172147e-08, 176,8.205275e-08,
+ 177,8.373020e-08, 178,8.267202e-08, 179,8.414423e-08, 180,8.393176e-08, 181,8.422727e-08, 182,8.136492e-08, 183,8.384440e-08, 184,8.258176e-08,
+ 185,8.230466e-08, 186,8.431092e-08, 187,8.328447e-08, 188,8.230796e-08, 189,8.127236e-08, 190,8.384003e-08, 191,7.975687e-08, 192,8.330730e-08,
+ 193,8.149589e-08, 194,8.332553e-08, 195,8.153472e-08, 196,8.271637e-08, 197,8.191369e-08, 198,8.079093e-08, 199,8.428311e-08, 200,8.155534e-08,
+ 201,8.206599e-08, 202,8.360265e-08, 203,8.433407e-08, 204,8.153308e-08, 205,8.095414e-08, 206,8.001690e-08, 207,8.398344e-08, 208,8.360852e-08,
+ 209,8.362295e-08, 210,8.073576e-08, 211,8.098679e-08, 212,8.435891e-08, 213,8.017127e-08, 214,7.971266e-08, 215,8.140859e-08, 216,8.194168e-08,
+ 217,8.031674e-08, 218,8.350610e-08, 219,8.358760e-08, 220,8.163804e-08, 221,8.236596e-08, 222,8.154801e-08, 223,8.230548e-08, 224,8.443179e-08,
+ 225,8.383670e-08, 226,8.281958e-08, 227,8.316489e-08, 228,8.299536e-08, 229,8.287193e-08, 230,8.179326e-08, 231,8.014051e-08, 232,8.082133e-08,
+ 233,8.150495e-08, 234,8.147743e-08, 235,8.431106e-08, 236,8.102687e-08, 237,8.358829e-08, 238,7.975180e-08, 239,8.322245e-08, 240,8.203775e-08,
+ 241,8.145032e-08, 242,8.090457e-08, 243,8.187992e-08, 244,8.349560e-08, 245,8.038044e-08, 246,8.120266e-08, 247,8.375538e-08, 248,8.406740e-08,
+ 249,8.299684e-08, 250,8.341729e-08, 251,8.209557e-08, 252,8.429457e-08)
.param L4R=table(run, 1,4.086792e-01, 2,4.339584e-01, 3,5.048075e-01, 4,3.451930e-01, 5,4.723652e-01, 6,5.548000e-01, 7,5.153731e-01, 8,4.995263e-01,
+ 9,3.868456e-01, 10,5.189469e-01, 11,3.547706e-01, 12,4.206063e-01, 13,5.120349e-01, 14,3.476243e-01, 15,4.566916e-01, 16,4.369986e-01,
+ 17,3.752769e-01, 18,4.664963e-01, 19,5.309676e-01, 20,3.897125e-01, 21,4.765495e-01, 22,3.837853e-01, 23,4.341419e-01, 24,3.644216e-01,
+ 25,5.025841e-01, 26,3.652138e-01, 27,4.348606e-01, 28,3.423938e-01, 29,3.439977e-01, 30,3.512280e-01, 31,3.614301e-01, 32,4.612181e-01,
+ 33,3.410134e-01, 34,3.689384e-01, 35,3.554163e-01, 36,4.339182e-01, 37,4.312054e-01, 38,3.638788e-01, 39,4.577079e-01, 40,4.992258e-01,
+ 41,4.779753e-01, 42,4.838889e-01, 43,4.811192e-01, 44,3.912606e-01, 45,3.857307e-01, 46,3.535887e-01, 47,3.957451e-01, 48,4.033106e-01,
+ 49,3.586697e-01, 50,4.185020e-01, 51,4.703232e-01, 52,4.498607e-01, 53,5.666000e-01, 54,3.668040e-01, 55,3.493073e-01, 56,3.949012e-01,
+ 57,4.165273e-01, 58,3.554732e-01, 59,5.005011e-01, 60,5.360275e-01, 61,4.233197e-01, 62,4.706508e-01, 63,3.571267e-01, 64,5.280529e-01,
+ 65,4.869364e-01, 66,4.075372e-01, 67,4.674581e-01, 68,4.257228e-01, 69,5.370785e-01, 70,4.349095e-01, 71,3.705033e-01, 72,4.480787e-01,
+ 73,3.878812e-01, 74,3.804751e-01, 75,4.095296e-01, 76,4.469785e-01, 77,3.307342e-01, 78,5.526930e-01, 79,3.709187e-01, 80,3.522692e-01,
+ 81,4.920899e-01, 82,3.828979e-01, 83,3.672269e-01, 84,3.563399e-01, 85,4.278089e-01, 86,4.171356e-01, 87,5.463481e-01, 88,3.658365e-01,
+ 89,5.211532e-01, 90,3.788022e-01, 91,5.009348e-01, 92,5.294716e-01, 93,4.362904e-01, 94,4.343434e-01, 95,4.804406e-01, 96,4.178574e-01,
+ 97,3.499898e-01, 98,5.258501e-01, 99,3.697706e-01, 100,4.083595e-01, 101,3.935616e-01, 102,3.817096e-01, 103,4.062773e-01, 104,4.961806e-01,
+ 105,4.515856e-01, 106,5.177582e-01, 107,3.572576e-01, 108,5.518222e-01, 109,4.485857e-01, 110,4.008713e-01, 111,3.988845e-01, 112,4.505769e-01,
+ 113,3.931349e-01, 114,3.677590e-01, 115,3.633125e-01, 116,5.431442e-01, 117,3.306413e-01, 118,4.264350e-01, 119,5.392427e-01, 120,4.110862e-01,
+ 121,4.953463e-01, 122,5.428153e-01, 123,3.464726e-01, 124,4.567124e-01, 125,4.401935e-01, 126,3.475670e-01, 127,4.321701e-01, 128,5.096358e-01,
+ 129,4.568020e-01, 130,3.548675e-01, 131,5.334561e-01, 132,3.499949e-01, 133,3.426752e-01, 134,5.326598e-01, 135,4.825841e-01, 136,4.067726e-01,
+ 137,5.106918e-01, 138,5.043799e-01, 139,3.848490e-01, 140,3.553056e-01, 141,4.478783e-01, 142,3.520284e-01, 143,3.721079e-01, 144,4.142656e-01,
+ 145,3.759037e-01, 146,4.635555e-01, 147,3.621838e-01, 148,4.862855e-01, 149,3.577032e-01, 150,5.189539e-01, 151,4.880679e-01, 152,5.197766e-01,
+ 153,5.200120e-01, 154,4.448208e-01, 155,4.077136e-01, 156,3.482115e-01, 157,4.217983e-01, 158,3.890420e-01, 159,3.624360e-01, 160,5.644534e-01,
+ 161,4.250868e-01, 162,5.216013e-01, 163,4.607178e-01, 164,3.621203e-01, 165,4.515262e-01, 166,3.401201e-01, 167,3.759717e-01, 168,3.841967e-01,
+ 169,3.491626e-01, 170,3.929804e-01, 171,5.130990e-01, 172,3.704018e-01, 173,5.339583e-01, 174,5.574631e-01, 175,3.979895e-01, 176,5.257548e-01,
+ 177,5.343952e-01, 178,5.517462e-01, 179,4.047845e-01, 180,3.639840e-01, 181,3.672218e-01, 182,3.777207e-01, 183,3.636567e-01, 184,5.325089e-01,
+ 185,4.597846e-01, 186,4.759312e-01, 187,5.059211e-01, 188,3.960695e-01, 189,3.823578e-01, 190,3.650596e-01, 191,5.042228e-01, 192,4.687842e-01,
+ 193,5.009861e-01, 194,5.079833e-01, 195,5.091560e-01, 196,4.838460e-01, 197,3.850166e-01, 198,4.158518e-01, 199,4.988753e-01, 200,4.215571e-01,
+ 201,3.412434e-01, 202,4.511864e-01, 203,4.967805e-01, 204,3.518693e-01, 205,4.092150e-01, 206,3.941161e-01, 207,3.538511e-01, 208,3.979120e-01,
+ 209,5.605066e-01, 210,3.331874e-01, 211,4.554583e-01, 212,5.506233e-01, 213,4.037587e-01, 214,4.269625e-01, 215,4.431672e-01, 216,4.275730e-01,
+ 217,3.365706e-01, 218,4.323127e-01, 219,5.541705e-01, 220,4.029680e-01, 221,3.739063e-01, 222,3.870624e-01, 223,5.483886e-01, 224,4.771205e-01,
+ 225,3.508518e-01, 226,3.778901e-01, 227,3.681544e-01, 228,3.835144e-01, 229,3.660763e-01, 230,5.099502e-01, 231,3.656332e-01, 232,4.179760e-01,
+ 233,4.835269e-01, 234,4.722900e-01, 235,4.168185e-01, 236,4.434563e-01, 237,5.672049e-01, 238,4.309054e-01, 239,4.818456e-01, 240,4.872554e-01,
+ 241,3.462764e-01, 242,3.747235e-01, 243,3.814760e-01, 244,4.605823e-01, 245,3.730601e-01, 246,4.874714e-01, 247,3.636096e-01, 248,4.025068e-01,
+ 249,4.651450e-01, 250,4.818870e-01, 251,3.634384e-01, 252,3.824200e-01)
.param L4C=table(run, 1,2.383299e-13, 2,2.273593e-13, 3,1.906590e-13, 4,2.569371e-13, 5,1.423882e-13, 6,1.958857e-13, 7,1.572455e-13, 8,1.762905e-13,
+ 9,1.675469e-13, 10,1.724187e-13, 11,2.006047e-13, 12,1.667319e-13, 13,2.890459e-13, 14,2.131744e-13, 15,2.570433e-13, 16,1.982709e-13,
+ 17,1.809255e-13, 18,2.269108e-13, 19,1.358038e-13, 20,2.471247e-13, 21,1.274089e-13, 22,1.614380e-13, 23,1.451185e-13, 24,2.246123e-13,
+ 25,1.472429e-13, 26,1.669845e-13, 27,2.265934e-13, 28,2.255987e-13, 29,1.764249e-13, 30,2.730112e-13, 31,1.400719e-13, 32,1.920935e-13,
+ 33,1.517649e-13, 34,1.963517e-13, 35,2.126783e-13, 36,2.748941e-13, 37,1.735348e-13, 38,3.129475e-13, 39,2.228694e-13, 40,1.676568e-13,
+ 41,2.978766e-13, 42,1.938606e-13, 43,3.284225e-13, 44,3.295913e-13, 45,2.857193e-13, 46,2.030845e-13, 47,1.605536e-13, 48,2.956185e-13,
+ 49,2.984567e-13, 50,2.228932e-13, 51,1.972449e-13, 52,1.384166e-13, 53,2.457336e-13, 54,1.893372e-13, 55,2.539555e-13, 56,2.285451e-13,
+ 57,1.908680e-13, 58,2.886823e-13, 59,2.915860e-13, 60,1.536997e-13, 61,1.807410e-13, 62,1.513021e-13, 63,1.339451e-13, 64,1.771688e-13,
+ 65,1.888544e-13, 66,2.004168e-13, 67,2.543990e-13, 68,1.520059e-13, 69,2.148867e-13, 70,2.191179e-13, 71,1.628339e-13, 72,1.950918e-13,
+ 73,1.751985e-13, 74,3.079152e-13, 75,1.745560e-13, 76,2.597357e-13, 77,2.618961e-13, 78,1.609592e-13, 79,2.096704e-13, 80,2.497106e-13,
+ 81,1.916053e-13, 82,2.444780e-13, 83,1.413760e-13, 84,1.573920e-13, 85,2.723740e-13, 86,2.222820e-13, 87,3.095288e-13, 88,2.126451e-13,
+ 89,2.573019e-13, 90,1.966599e-13, 91,1.573893e-13, 92,1.637128e-13, 93,1.725676e-13, 94,1.575896e-13, 95,1.719591e-13, 96,2.217543e-13,
+ 97,2.214846e-13, 98,1.820003e-13, 99,2.961411e-13, 100,2.687376e-13, 101,1.603096e-13, 102,2.099925e-13, 103,1.919613e-13, 104,1.438978e-13,
+ 105,2.990854e-13, 106,3.150726e-13, 107,1.749287e-13, 108,1.614473e-13, 109,1.635799e-13, 110,1.583719e-13, 111,1.428486e-13, 112,1.625551e-13,
+ 113,2.050027e-13, 114,1.720720e-13, 115,2.612701e-13, 116,1.958221e-13, 117,3.179555e-13, 118,3.265191e-13, 119,3.276679e-13, 120,2.005653e-13,
+ 121,1.604127e-13, 122,2.435301e-13, 123,2.729529e-13, 124,1.336801e-13, 125,2.230687e-13, 126,1.376348e-13, 127,1.575416e-13, 128,1.881587e-13,
+ 129,1.733979e-13, 130,1.911192e-13, 131,1.981015e-13, 132,1.823123e-13, 133,2.621962e-13, 134,1.982088e-13, 135,2.772512e-13, 136,2.364478e-13,
+ 137,1.363420e-13, 138,1.703075e-13, 139,1.839779e-13, 140,2.111561e-13, 141,1.749766e-13, 142,1.635647e-13, 143,3.037078e-13, 144,2.848682e-13,
+ 145,2.121184e-13, 146,2.639873e-13, 147,2.589889e-13, 148,1.829598e-13, 149,2.288853e-13, 150,1.910157e-13, 151,1.943342e-13, 152,2.998058e-13,
+ 153,1.927532e-13, 154,2.381783e-13, 155,2.445229e-13, 156,2.762216e-13, 157,2.013144e-13, 158,1.929594e-13, 159,1.802297e-13, 160,1.275683e-13,
+ 161,1.836250e-13, 162,1.877888e-13, 163,2.152745e-13, 164,3.204224e-13, 165,1.558262e-13, 166,1.884457e-13, 167,1.777174e-13, 168,2.942651e-13,
+ 169,2.150159e-13, 170,2.064405e-13, 171,1.635774e-13, 172,1.789311e-13, 173,1.214358e-13, 174,2.200068e-13, 175,2.030194e-13, 176,1.218365e-13,
+ 177,1.877901e-13, 178,2.026852e-13, 179,1.688209e-13, 180,1.668380e-13, 181,1.380804e-13, 182,2.519715e-13, 183,2.059793e-13, 184,1.527119e-13,
+ 185,1.390944e-13, 186,2.918557e-13, 187,1.547258e-13, 188,1.319610e-13, 189,1.739803e-13, 190,1.352835e-13, 191,1.899569e-13, 192,3.317711e-13,
+ 193,1.563299e-13, 194,1.587708e-13, 195,1.910245e-13, 196,1.810125e-13, 197,3.210644e-13, 198,3.352637e-13, 199,1.253572e-13, 200,2.993075e-13,
+ 201,1.422296e-13, 202,2.819169e-13, 203,2.156266e-13, 204,1.889495e-13, 205,2.793116e-13, 206,1.354725e-13, 207,2.960018e-13, 208,1.779125e-13,
+ 209,1.672904e-13, 210,1.793356e-13, 211,2.144589e-13, 212,1.443732e-13, 213,2.333440e-13, 214,1.824911e-13, 215,1.718957e-13, 216,1.736742e-13,
+ 217,2.475851e-13, 218,1.843427e-13, 219,1.622226e-13, 220,2.454815e-13, 221,1.766691e-13, 222,1.829343e-13, 223,1.911063e-13, 224,2.136556e-13,
+ 225,1.943707e-13, 226,1.646281e-13, 227,2.065666e-13, 228,2.234626e-13, 229,2.742805e-13, 230,1.866806e-13, 231,2.431598e-13, 232,2.100550e-13,
+ 233,2.193016e-13, 234,1.870709e-13, 235,2.641109e-13, 236,2.962419e-13, 237,2.125337e-13, 238,2.327119e-13, 239,2.169524e-13, 240,1.966502e-13,
+ 241,2.976967e-13, 242,2.569248e-13, 243,1.361742e-13, 244,2.060880e-13, 245,2.046871e-13, 246,1.889456e-13, 247,1.310833e-13, 248,2.043349e-13,
+ 249,1.730245e-13, 250,2.484111e-13, 251,2.534968e-13, 252,1.623382e-13)
.param L4Ltr=table(run, 1,1.000000e-09, 2,1.000000e-09, 3,1.460638e-09, 4,5.940463e-10, 5,6.928580e-10, 6,1.555784e-09, 7,1.030228e-09, 8,8.944996e-10,
+ 9,1.007865e-09, 10,1.942250e-09, 11,1.692119e-09, 12,1.324158e-09, 13,9.483277e-10, 14,1.561523e-09, 15,8.505980e-10, 16,1.904980e-09,
+ 17,1.059121e-09, 18,1.496227e-09, 19,1.126142e-09, 20,1.340958e-09, 21,1.715591e-09, 22,5.212374e-10, 23,7.534779e-10, 24,1.831103e-09,
+ 25,7.369394e-10, 26,1.030898e-09, 27,1.911104e-09, 28,1.208846e-09, 29,5.325622e-10, 30,1.300177e-09, 31,8.013736e-10, 32,9.201827e-10,
+ 33,5.272506e-10, 34,1.427404e-09, 35,1.888825e-09, 36,1.328316e-09, 37,1.658274e-09, 38,1.452997e-09, 39,1.714488e-09, 40,1.129710e-09,
+ 41,1.682281e-09, 42,9.928928e-10, 43,1.903375e-09, 44,5.590396e-10, 45,9.453466e-10, 46,1.743527e-09, 47,5.098740e-10, 48,7.678099e-10,
+ 49,1.420608e-09, 50,1.348620e-09, 51,1.205297e-09, 52,1.385959e-09, 53,1.425251e-09, 54,1.874126e-09, 55,1.346061e-09, 56,1.782820e-09,
+ 57,1.923207e-09, 58,5.000574e-10, 59,8.346796e-10, 60,1.129198e-09, 61,1.021898e-09, 62,5.939877e-10, 63,9.267305e-10, 64,9.554832e-10,
+ 65,1.750214e-09, 66,7.870551e-10, 67,1.139023e-09, 68,1.018887e-09, 69,1.352227e-09, 70,1.511107e-09, 71,1.439206e-09, 72,6.109390e-10,
+ 73,7.861929e-10, 74,1.278313e-09, 75,1.282796e-09, 76,1.201407e-09, 77,1.052896e-09, 78,7.172403e-10, 79,1.900260e-09, 80,1.986061e-09,
+ 81,1.601940e-09, 82,1.711076e-09, 83,9.854326e-10, 84,1.322504e-09, 85,1.993701e-09, 86,1.819185e-09, 87,9.056517e-10, 88,1.630533e-09,
+ 89,1.713680e-09, 90,9.439459e-10, 91,1.641003e-09, 92,1.620173e-09, 93,1.849553e-09, 94,5.106535e-10, 95,1.383911e-09, 96,1.437743e-09,
+ 97,1.594303e-09, 98,1.220559e-09, 99,1.621654e-09, 100,1.872806e-09, 101,1.114669e-09, 102,1.391536e-09, 103,1.513815e-09, 104,1.540791e-09,
+ 105,1.558637e-09, 106,1.879480e-09, 107,8.039906e-10, 108,1.488195e-09, 109,1.806187e-09, 110,1.257634e-09, 111,6.915814e-10, 112,1.618574e-09,
+ 113,1.273367e-09, 114,1.671718e-09, 115,1.101508e-09, 116,5.886984e-10, 117,7.918731e-10, 118,1.795076e-09, 119,1.745616e-09, 120,6.209800e-10,
+ 121,1.225569e-09, 122,9.170638e-10, 123,7.910977e-10, 124,9.225862e-10, 125,1.204462e-09, 126,1.004516e-09, 127,1.833715e-09, 128,6.294466e-10,
+ 129,1.217233e-09, 130,1.742536e-09, 131,5.151195e-10, 132,1.833512e-09, 133,7.693281e-10, 134,1.324828e-09, 135,1.665045e-09, 136,1.247256e-09,
+ 137,5.714708e-10, 138,1.096166e-09, 139,1.132435e-09, 140,1.203471e-09, 141,1.528318e-09, 142,1.242680e-09, 143,1.461290e-09, 144,1.714081e-09,
+ 145,1.448655e-09, 146,1.349296e-09, 147,1.657562e-09, 148,8.421379e-10, 149,1.735724e-09, 150,1.741420e-09, 151,9.997139e-10, 152,1.185742e-09,
+ 153,9.966481e-10, 154,1.493269e-09, 155,8.161397e-10, 156,1.843420e-09, 157,1.372791e-09, 158,6.165579e-10, 159,8.043095e-10, 160,1.028201e-09,
+ 161,8.106181e-10, 162,1.307236e-09, 163,1.030114e-09, 164,1.811373e-09, 165,1.994989e-09, 166,1.632949e-09, 167,8.335462e-10, 168,1.561317e-09,
+ 169,1.979677e-09, 170,1.837230e-09, 171,1.083349e-09, 172,6.236532e-10, 173,1.786781e-09, 174,1.462036e-09, 175,1.763838e-09, 176,1.130407e-09,
+ 177,1.824932e-09, 178,1.827534e-09, 179,1.638454e-09, 180,1.346338e-09, 181,1.849227e-09, 182,1.423173e-09, 183,9.247743e-10, 184,1.518202e-09,
+ 185,1.509192e-09, 186,9.337922e-10, 187,1.811593e-09, 188,1.212834e-09, 189,1.252631e-09, 190,1.184506e-09, 191,1.730623e-09, 192,6.122500e-10,
+ 193,1.153885e-09, 194,8.268674e-10, 195,1.176386e-09, 196,1.271359e-09, 197,1.612901e-09, 198,7.020785e-10, 199,1.049429e-09, 200,1.032012e-09,
+ 201,1.194353e-09, 202,1.943178e-09, 203,1.441331e-09, 204,6.108025e-10, 205,6.907656e-10, 206,1.762733e-09, 207,5.209474e-10, 208,1.568331e-09,
+ 209,9.501942e-10, 210,1.790584e-09, 211,6.402155e-10, 212,8.607990e-10, 213,1.572451e-09, 214,1.810537e-09, 215,9.416413e-10, 216,1.516259e-09,
+ 217,1.550776e-09, 218,1.132180e-09, 219,7.312986e-10, 220,1.016767e-09, 221,1.055506e-09, 222,1.103032e-09, 223,1.934720e-09, 224,1.673758e-09,
+ 225,1.554911e-09, 226,1.160265e-09, 227,1.992595e-09, 228,1.123626e-09, 229,9.594573e-10, 230,1.708654e-09, 231,9.704615e-10, 232,1.498319e-09,
+ 233,1.022490e-09, 234,8.718202e-10, 235,1.432709e-09, 236,7.313818e-10, 237,1.585908e-09, 238,8.074633e-10, 239,1.321733e-09, 240,1.663270e-09,
+ 241,1.641916e-09, 242,1.142249e-09, 243,7.574887e-10, 244,1.182276e-09, 245,1.488740e-09, 246,1.460681e-09, 247,1.053664e-09, 248,1.203147e-09,
+ 249,8.488494e-10, 250,1.350435e-09, 251,1.320404e-09, 252,1.063815e-09)
.param L6L=table(run, 1,6.596000e-08, 2,7.004000e-08, 3,6.722745e-08, 4,6.832059e-08, 5,6.916076e-08, 6,6.923544e-08, 7,6.696899e-08, 8,6.684395e-08,
+ 9,6.914233e-08, 10,6.684524e-08, 11,6.759165e-08, 12,6.914293e-08, 13,6.697825e-08, 14,6.668127e-08, 15,6.600228e-08, 16,6.728775e-08,
+ 17,6.908746e-08, 18,6.810600e-08, 19,6.603762e-08, 20,6.725393e-08, 21,6.718146e-08, 22,6.710295e-08, 23,6.851139e-08, 24,6.990314e-08,
+ 25,6.618134e-08, 26,6.701046e-08, 27,6.929123e-08, 28,6.837310e-08, 29,6.928423e-08, 30,6.835211e-08, 31,6.941978e-08, 32,6.705115e-08,
+ 33,6.759727e-08, 34,6.761097e-08, 35,6.720836e-08, 36,6.823130e-08, 37,6.881087e-08, 38,6.850584e-08, 39,6.976326e-08, 40,6.865259e-08,
+ 41,6.903452e-08, 42,6.842596e-08, 43,6.706567e-08, 44,6.670217e-08, 45,6.974381e-08, 46,6.837793e-08, 47,6.951295e-08, 48,6.809937e-08,
+ 49,6.993638e-08, 50,6.678425e-08, 51,6.649807e-08, 52,6.853550e-08, 53,6.886278e-08, 54,6.945949e-08, 55,6.899106e-08, 56,6.982659e-08,
+ 57,6.755538e-08, 58,6.903058e-08, 59,6.941710e-08, 60,6.987234e-08, 61,6.851872e-08, 62,6.826041e-08, 63,6.996229e-08, 64,6.895100e-08,
+ 65,6.598035e-08, 66,6.992260e-08, 67,6.950117e-08, 68,6.821026e-08, 69,6.791478e-08, 70,6.600363e-08, 71,6.864612e-08, 72,6.928352e-08,
+ 73,6.715308e-08, 74,6.773952e-08, 75,6.657239e-08, 76,6.937335e-08, 77,6.750318e-08, 78,6.621894e-08, 79,6.868946e-08, 80,6.722296e-08,
+ 81,6.900479e-08, 82,6.710068e-08, 83,6.951377e-08, 84,6.612321e-08, 85,6.816637e-08, 86,6.872809e-08, 87,6.963600e-08, 88,6.847109e-08,
+ 89,6.731419e-08, 90,6.607212e-08, 91,6.597151e-08, 92,6.766563e-08, 93,6.747481e-08, 94,6.739534e-08, 95,6.865716e-08, 96,6.654649e-08,
+ 97,6.782985e-08, 98,6.639002e-08, 99,6.703511e-08, 100,6.739039e-08, 101,6.754424e-08, 102,6.783304e-08, 103,6.871400e-08, 104,6.751078e-08,
+ 105,6.982169e-08, 106,6.930123e-08, 107,6.826401e-08, 108,6.781615e-08, 109,6.851496e-08, 110,6.817190e-08, 111,6.953975e-08, 112,6.748689e-08,
+ 113,6.754792e-08, 114,6.886978e-08, 115,6.834752e-08, 116,6.933706e-08, 117,6.752507e-08, 118,6.901568e-08, 119,6.910737e-08, 120,6.651872e-08,
+ 121,6.844545e-08, 122,6.770440e-08, 123,6.919664e-08, 124,6.836674e-08, 125,6.828570e-08, 126,6.684279e-08, 127,6.640206e-08, 128,6.937053e-08,
+ 129,6.873505e-08, 130,6.822168e-08, 131,6.906463e-08, 132,6.675277e-08, 133,6.748522e-08, 134,6.874411e-08, 135,6.913536e-08, 136,6.665461e-08,
+ 137,6.690534e-08, 138,6.725734e-08, 139,6.893966e-08, 140,6.840043e-08, 141,6.925250e-08, 142,6.647066e-08, 143,6.790949e-08, 144,6.662270e-08,
+ 145,6.970567e-08, 146,6.821770e-08, 147,6.886039e-08, 148,6.734005e-08, 149,6.649935e-08, 150,6.897979e-08, 151,6.909968e-08, 152,6.697283e-08,
+ 153,6.607547e-08, 154,6.972477e-08, 155,6.934276e-08, 156,6.965840e-08, 157,6.767673e-08, 158,6.633143e-08, 159,6.748700e-08, 160,6.886313e-08,
+ 161,6.808122e-08, 162,6.870504e-08, 163,6.986587e-08, 164,6.632296e-08, 165,6.863710e-08, 166,6.749956e-08, 167,6.753540e-08, 168,6.979166e-08,
+ 169,6.672567e-08, 170,6.874625e-08, 171,6.998477e-08, 172,6.958038e-08, 173,6.771877e-08, 174,6.817254e-08, 175,6.677462e-08, 176,6.875282e-08,
+ 177,6.675732e-08, 178,6.906086e-08, 179,6.746895e-08, 180,6.787126e-08, 181,6.977465e-08, 182,6.955671e-08, 183,6.752693e-08, 184,6.948847e-08,
+ 185,6.746960e-08, 186,6.722269e-08, 187,6.881923e-08, 188,6.688799e-08, 189,6.617730e-08, 190,6.751206e-08, 191,6.990010e-08, 192,6.909624e-08,
+ 193,6.943891e-08, 194,6.917694e-08, 195,6.619879e-08, 196,6.980613e-08, 197,6.886553e-08, 198,6.864571e-08, 199,6.722591e-08, 200,6.795381e-08,
+ 201,6.746741e-08, 202,6.923349e-08, 203,6.708366e-08, 204,6.793623e-08, 205,6.872979e-08, 206,6.714241e-08, 207,6.818525e-08, 208,6.951686e-08,
+ 209,6.647520e-08, 210,6.965994e-08, 211,6.691953e-08, 212,6.930876e-08, 213,6.784883e-08, 214,6.694269e-08, 215,6.791910e-08, 216,6.711738e-08,
+ 217,6.651350e-08, 218,6.671541e-08, 219,6.604968e-08, 220,6.981149e-08, 221,6.974127e-08, 222,6.725298e-08, 223,6.771949e-08, 224,6.709910e-08,
+ 225,6.783918e-08, 226,6.866479e-08, 227,6.744442e-08, 228,6.863975e-08, 229,6.870326e-08, 230,6.924497e-08, 231,6.686013e-08, 232,6.992474e-08,
+ 233,6.610012e-08, 234,6.818038e-08, 235,6.899396e-08, 236,6.852324e-08, 237,7.002037e-08, 238,6.907790e-08, 239,6.940791e-08, 240,6.652060e-08,
+ 241,6.986996e-08, 242,6.777691e-08, 243,6.865500e-08, 244,6.695073e-08, 245,6.884759e-08, 246,6.602532e-08, 247,6.895039e-08, 248,6.606581e-08,
+ 249,6.998975e-08, 250,6.846720e-08, 251,6.830885e-08, 252,6.636376e-08)
.param L6R=table(run, 1,3.488362e-01, 2,3.704136e-01, 3,2.933047e-01, 4,4.814940e-01, 5,4.782189e-01, 6,2.984300e-01, 7,2.865637e-01, 8,3.545355e-01,
+ 9,4.599692e-01, 10,3.951614e-01, 11,2.884586e-01, 12,3.842427e-01, 13,3.580353e-01, 14,3.603023e-01, 15,2.879281e-01, 16,4.627424e-01,
+ 17,3.417596e-01, 18,3.525138e-01, 19,2.870038e-01, 20,4.091334e-01, 21,3.079596e-01, 22,3.600367e-01, 23,3.539940e-01, 24,3.206302e-01,
+ 25,3.888086e-01, 26,3.243276e-01, 27,3.735278e-01, 28,2.902488e-01, 29,3.083810e-01, 30,3.262664e-01, 31,4.005808e-01, 32,4.453142e-01,
+ 33,3.233719e-01, 34,3.476467e-01, 35,3.173805e-01, 36,3.467699e-01, 37,4.357532e-01, 38,3.749858e-01, 39,4.673933e-01, 40,2.917359e-01,
+ 41,4.218348e-01, 42,3.460185e-01, 43,2.855170e-01, 44,3.267126e-01, 45,2.997050e-01, 46,2.913217e-01, 47,4.391461e-01, 48,3.790637e-01,
+ 49,4.465157e-01, 50,4.439736e-01, 51,4.237437e-01, 52,4.797638e-01, 53,3.976620e-01, 54,4.042354e-01, 55,2.956496e-01, 56,4.279637e-01,
+ 57,3.132272e-01, 58,3.183891e-01, 59,4.845837e-01, 60,4.010902e-01, 61,3.419794e-01, 62,3.774331e-01, 63,4.300510e-01, 64,4.062813e-01,
+ 65,3.410272e-01, 66,2.972700e-01, 67,3.310690e-01, 68,4.479517e-01, 69,3.571491e-01, 70,4.257660e-01, 71,2.950240e-01, 72,3.295452e-01,
+ 73,3.838618e-01, 74,3.846189e-01, 75,3.977221e-01, 76,4.246798e-01, 77,3.493820e-01, 78,3.903944e-01, 79,2.986635e-01, 80,3.524823e-01,
+ 81,4.736342e-01, 82,3.013040e-01, 83,2.997137e-01, 84,2.910886e-01, 85,3.333290e-01, 86,4.140682e-01, 87,4.624919e-01, 88,3.849162e-01,
+ 89,2.955935e-01, 90,4.574336e-01, 91,3.025954e-01, 92,4.211334e-01, 93,3.445435e-01, 94,3.830177e-01, 95,3.789122e-01, 96,4.355460e-01,
+ 97,4.105775e-01, 98,2.887132e-01, 99,4.265394e-01, 100,3.342278e-01, 101,3.784209e-01, 102,3.467479e-01, 103,3.841912e-01, 104,4.527926e-01,
+ 105,3.538260e-01, 106,3.418860e-01, 107,3.131852e-01, 108,3.024080e-01, 109,3.569428e-01, 110,4.272452e-01, 111,3.425703e-01, 112,4.705884e-01,
+ 113,2.922915e-01, 114,3.762805e-01, 115,4.091048e-01, 116,3.439778e-01, 117,3.006795e-01, 118,3.451903e-01, 119,3.053371e-01, 120,3.025778e-01,
+ 121,4.749612e-01, 122,3.172491e-01, 123,3.743759e-01, 124,4.632268e-01, 125,4.106022e-01, 126,3.164034e-01, 127,3.339867e-01, 128,3.479941e-01,
+ 129,4.094012e-01, 130,3.462257e-01, 131,3.067360e-01, 132,4.389173e-01, 133,3.882351e-01, 134,3.351736e-01, 135,3.357766e-01, 136,3.778942e-01,
+ 137,2.855523e-01, 138,3.308499e-01, 139,3.037902e-01, 140,4.168475e-01, 141,3.272851e-01, 142,4.638043e-01, 143,3.953055e-01, 144,4.538328e-01,
+ 145,3.521683e-01, 146,3.392455e-01, 147,4.713098e-01, 148,4.117574e-01, 149,3.077496e-01, 150,4.098814e-01, 151,4.735563e-01, 152,3.542342e-01,
+ 153,4.470958e-01, 154,3.562828e-01, 155,3.829071e-01, 156,4.192912e-01, 157,3.271241e-01, 158,3.520563e-01, 159,4.034642e-01, 160,3.191841e-01,
+ 161,3.087135e-01, 162,3.118157e-01, 163,4.579083e-01, 164,3.993514e-01, 165,3.749569e-01, 166,4.071189e-01, 167,4.233091e-01, 168,4.505101e-01,
+ 169,3.155394e-01, 170,4.096036e-01, 171,4.213134e-01, 172,3.679113e-01, 173,4.028562e-01, 174,3.790963e-01, 175,3.690589e-01, 176,4.580489e-01,
+ 177,4.022902e-01, 178,3.808347e-01, 179,3.967578e-01, 180,3.062230e-01, 181,3.005316e-01, 182,4.296418e-01, 183,3.058374e-01, 184,3.705971e-01,
+ 185,3.006210e-01, 186,3.492980e-01, 187,3.408340e-01, 188,3.570657e-01, 189,2.847052e-01, 190,4.470947e-01, 191,4.264334e-01, 192,3.696999e-01,
+ 193,4.095409e-01, 194,3.455552e-01, 195,2.989905e-01, 196,3.397639e-01, 197,3.298582e-01, 198,4.042443e-01, 199,4.565031e-01, 200,2.895141e-01,
+ 201,3.750928e-01, 202,3.790381e-01, 203,4.612921e-01, 204,3.849281e-01, 205,3.492898e-01, 206,4.150411e-01, 207,3.819737e-01, 208,3.457494e-01,
+ 209,3.038411e-01, 210,4.351038e-01, 211,3.580443e-01, 212,3.450792e-01, 213,4.247098e-01, 214,3.875183e-01, 215,4.241297e-01, 216,4.043305e-01,
+ 217,4.052999e-01, 218,3.057537e-01, 219,3.901066e-01, 220,3.817186e-01, 221,3.032645e-01, 222,4.172079e-01, 223,3.049160e-01, 224,4.295304e-01,
+ 225,4.511737e-01, 226,3.275136e-01, 227,4.570947e-01, 228,3.375935e-01, 229,4.787196e-01, 230,3.051844e-01, 231,3.003185e-01, 232,4.513704e-01,
+ 233,3.826262e-01, 234,4.255785e-01, 235,3.229675e-01, 236,3.789361e-01, 237,3.063467e-01, 238,3.318029e-01, 239,3.783784e-01, 240,2.999959e-01,
+ 241,3.694469e-01, 242,2.966613e-01, 243,4.081119e-01, 244,3.393016e-01, 245,3.218484e-01, 246,2.882324e-01, 247,3.540769e-01, 248,3.154054e-01,
+ 249,3.807764e-01, 250,4.467022e-01, 251,3.248189e-01, 252,3.558170e-01)
.param L6C=table(run, 1,2.296805e-13, 2,2.192136e-13, 3,1.805035e-13, 4,3.085888e-13, 5,1.803487e-13, 6,2.690152e-13, 7,2.770958e-13, 8,3.103721e-13,
+ 9,2.411779e-13, 10,2.708579e-13, 11,1.428216e-13, 12,2.456789e-13, 13,2.278931e-13, 14,2.839935e-13, 15,1.220878e-13, 16,1.400050e-13,
+ 17,1.917443e-13, 18,1.862914e-13, 19,2.465275e-13, 20,1.298104e-13, 21,1.405534e-13, 22,1.663201e-13, 23,2.549580e-13, 24,1.227523e-13,
+ 25,2.427016e-13, 26,1.972312e-13, 27,1.428015e-13, 28,2.567426e-13, 29,1.687035e-13, 30,1.695710e-13, 31,1.332821e-13, 32,1.619866e-13,
+ 33,1.942532e-13, 34,1.318009e-13, 35,1.739912e-13, 36,2.592023e-13, 37,2.479665e-13, 38,1.356378e-13, 39,2.022205e-13, 40,1.523331e-13,
+ 41,1.242983e-13, 42,1.918629e-13, 43,2.997059e-13, 44,1.834578e-13, 45,2.108185e-13, 46,1.902891e-13, 47,1.361014e-13, 48,2.619890e-13,
+ 49,1.633395e-13, 50,1.665464e-13, 51,1.886739e-13, 52,2.158352e-13, 53,1.251121e-13, 54,1.933929e-13, 55,2.561870e-13, 56,2.796773e-13,
+ 57,3.049365e-13, 58,2.589604e-13, 59,1.776260e-13, 60,1.540087e-13, 61,2.988640e-13, 62,2.570735e-13, 63,2.436892e-13, 64,1.861497e-13,
+ 65,2.211284e-13, 66,2.075602e-13, 67,1.479385e-13, 68,2.425128e-13, 69,1.262261e-13, 70,1.414690e-13, 71,1.384956e-13, 72,2.628667e-13,
+ 73,1.409970e-13, 74,2.103183e-13, 75,2.536794e-13, 76,2.848996e-13, 77,3.060551e-13, 78,1.860289e-13, 79,1.512760e-13, 80,1.396830e-13,
+ 81,1.568269e-13, 82,1.976589e-13, 83,1.299796e-13, 84,1.815651e-13, 85,2.332130e-13, 86,1.521651e-13, 87,2.810833e-13, 88,1.850363e-13,
+ 89,2.924160e-13, 90,1.727401e-13, 91,3.365753e-13, 92,3.050832e-13, 93,1.639577e-13, 94,2.228202e-13, 95,1.402769e-13, 96,2.579705e-13,
+ 97,1.510207e-13, 98,2.668926e-13, 99,1.348400e-13, 100,2.179541e-13, 101,1.735576e-13, 102,1.659586e-13, 103,1.702964e-13, 104,1.633148e-13,
+ 105,1.577107e-13, 106,3.196194e-13, 107,2.926155e-13, 108,1.574754e-13, 109,1.400326e-13, 110,1.690851e-13, 111,2.828694e-13, 112,1.776668e-13,
+ 113,1.422827e-13, 114,1.489130e-13, 115,1.125253e-13, 116,1.906129e-13, 117,1.870876e-13, 118,1.685868e-13, 119,1.701103e-13, 120,2.286288e-13,
+ 121,2.049326e-13, 122,1.756237e-13, 123,1.224093e-13, 124,1.861960e-13, 125,1.621194e-13, 126,2.798404e-13, 127,1.412072e-13, 128,1.427959e-13,
+ 129,2.627713e-13, 130,1.789982e-13, 131,1.482314e-13, 132,1.509035e-13, 133,1.550995e-13, 134,2.630906e-13, 135,2.787254e-13, 136,1.290795e-13,
+ 137,1.702609e-13, 138,1.318944e-13, 139,2.501030e-13, 140,1.710760e-13, 141,1.483489e-13, 142,1.748849e-13, 143,1.597391e-13, 144,1.913369e-13,
+ 145,1.369603e-13, 146,2.592853e-13, 147,1.744472e-13, 148,2.003317e-13, 149,1.959366e-13, 150,1.737208e-13, 151,2.316895e-13, 152,2.306163e-13,
+ 153,1.824879e-13, 154,1.502171e-13, 155,2.908079e-13, 156,1.967133e-13, 157,1.982645e-13, 158,2.602136e-13, 159,2.193028e-13, 160,1.400874e-13,
+ 161,1.229498e-13, 162,2.029316e-13, 163,1.841703e-13, 164,1.501307e-13, 165,2.619267e-13, 166,1.789645e-13, 167,1.746319e-13, 168,1.983846e-13,
+ 169,1.838458e-13, 170,1.383834e-13, 171,1.808457e-13, 172,1.474585e-13, 173,1.305494e-13, 174,2.741030e-13, 175,1.412967e-13, 176,1.363153e-13,
+ 177,2.225212e-13, 178,1.908336e-13, 179,1.275528e-13, 180,1.423465e-13, 181,1.651983e-13, 182,1.459554e-13, 183,1.469217e-13, 184,2.426146e-13,
+ 185,1.310754e-13, 186,1.381009e-13, 187,1.267902e-13, 188,2.041654e-13, 189,1.581835e-13, 190,2.867639e-13, 191,1.880608e-13, 192,2.605999e-13,
+ 193,2.865755e-13, 194,2.465697e-13, 195,2.741933e-13, 196,2.198661e-13, 197,3.084845e-13, 198,2.085295e-13, 199,2.668894e-13, 200,2.953714e-13,
+ 201,2.189467e-13, 202,1.834305e-13, 203,2.695638e-13, 204,1.843360e-13, 205,1.391248e-13, 206,2.992963e-13, 207,2.291734e-13, 208,1.172410e-13,
+ 209,2.003037e-13, 210,2.064485e-13, 211,1.384698e-13, 212,1.330310e-13, 213,2.086132e-13, 214,1.821720e-13, 215,1.368804e-13, 216,3.056576e-13,
+ 217,1.537411e-13, 218,2.066758e-13, 219,2.575732e-13, 220,1.189531e-13, 221,1.625533e-13, 222,3.342049e-13, 223,1.776692e-13, 224,2.585972e-13,
+ 225,2.883359e-13, 226,1.363227e-13, 227,1.886183e-13, 228,2.008993e-13, 229,1.755717e-13, 230,1.945969e-13, 231,1.774338e-13, 232,1.664470e-13,
+ 233,2.186078e-13, 234,2.381745e-13, 235,2.157248e-13, 236,1.592000e-13, 237,1.693682e-13, 238,1.365439e-13, 239,2.586411e-13, 240,2.422005e-13,
+ 241,2.000834e-13, 242,2.616779e-13, 243,1.779880e-13, 244,2.292699e-13, 245,2.077363e-13, 246,1.615052e-13, 247,1.546962e-13, 248,2.946529e-13,
+ 249,1.674293e-13, 250,1.827520e-13, 251,1.477553e-13, 252,2.726163e-13)
.param L6Ltr=table(run, 1,1.000000e-09, 2,1.000000e-09, 3,1.892262e-09, 4,1.699881e-09, 5,1.076820e-09, 6,8.108170e-10, 7,1.529760e-09, 8,1.521795e-09,
+ 9,1.780219e-09, 10,1.483543e-09, 11,9.718272e-10, 12,1.919761e-09, 13,1.561120e-09, 14,1.189715e-09, 15,1.505525e-09, 16,1.935765e-09,
+ 17,5.251958e-10, 18,1.246098e-09, 19,1.243195e-09, 20,6.944217e-10, 21,5.563414e-10, 22,6.621346e-10, 23,1.751323e-09, 24,1.071615e-09,
+ 25,1.883029e-09, 26,6.088187e-10, 27,1.574206e-09, 28,1.032030e-09, 29,1.264814e-09, 30,1.909970e-09, 31,1.047861e-09, 32,7.279028e-10,
+ 33,1.854383e-09, 34,7.527541e-10, 35,1.006303e-09, 36,8.960336e-10, 37,1.853098e-09, 38,1.911583e-09, 39,1.016850e-09, 40,1.066747e-09,
+ 41,1.485595e-09, 42,1.203972e-09, 43,7.636281e-10, 44,1.145890e-09, 45,9.739286e-10, 46,1.607138e-09, 47,1.035355e-09, 48,1.417918e-09,
+ 49,1.504493e-09, 50,1.395058e-09, 51,1.126538e-09, 52,5.782619e-10, 53,6.440042e-10, 54,1.928605e-09, 55,1.969096e-09, 56,1.955867e-09,
+ 57,1.035069e-09, 58,1.413364e-09, 59,1.525326e-09, 60,8.659334e-10, 61,1.518477e-09, 62,1.884764e-09, 63,1.278879e-09, 64,1.293038e-09,
+ 65,1.637588e-09, 66,9.451211e-10, 67,6.817744e-10, 68,1.564186e-09, 69,6.638057e-10, 70,9.823379e-10, 71,1.189432e-09, 72,1.147497e-09,
+ 73,7.873635e-10, 74,6.030491e-10, 75,1.650285e-09, 76,8.108179e-10, 77,1.889394e-09, 78,1.765925e-09, 79,1.818005e-09, 80,1.731045e-09,
+ 81,5.478287e-10, 82,1.384852e-09, 83,6.587025e-10, 84,1.646493e-09, 85,1.025261e-09, 86,1.878525e-09, 87,8.609114e-10, 88,8.115877e-10,
+ 89,1.255585e-09, 90,5.872881e-10, 91,5.853530e-10, 92,1.768350e-09, 93,7.190840e-10, 94,1.189148e-09, 95,7.211237e-10, 96,6.627720e-10,
+ 97,1.282655e-09, 98,1.093515e-09, 99,6.733884e-10, 100,1.004586e-09, 101,7.453474e-10, 102,7.902938e-10, 103,1.073983e-09, 104,6.566141e-10,
+ 105,1.776952e-09, 106,1.659252e-09, 107,7.785920e-10, 108,7.968566e-10, 109,8.239341e-10, 110,1.760585e-09, 111,1.028688e-09, 112,1.051818e-09,
+ 113,1.599379e-09, 114,1.296393e-09, 115,1.522883e-09, 116,1.461392e-09, 117,9.284698e-10, 118,1.826248e-09, 119,8.002093e-10, 120,1.895590e-09,
+ 121,9.110204e-10, 122,1.018652e-09, 123,1.276388e-09, 124,1.356109e-09, 125,1.584869e-09, 126,1.404389e-09, 127,1.878752e-09, 128,1.182318e-09,
+ 129,1.712923e-09, 130,1.742499e-09, 131,1.807302e-09, 132,1.765722e-09, 133,5.435987e-10, 134,1.458555e-09, 135,1.066457e-09, 136,1.002646e-09,
+ 137,1.436381e-09, 138,1.213934e-09, 139,9.345727e-10, 140,6.994863e-10, 141,1.046525e-09, 142,6.270573e-10, 143,1.103873e-09, 144,1.768272e-09,
+ 145,1.460700e-09, 146,7.971900e-10, 147,1.718215e-09, 148,9.907413e-10, 149,5.743121e-10, 150,1.603073e-09, 151,6.020936e-10, 152,1.226695e-09,
+ 153,1.672741e-09, 154,8.310582e-10, 155,1.678561e-09, 156,1.083324e-09, 157,7.475276e-10, 158,1.501617e-09, 159,1.992066e-09, 160,1.444638e-09,
+ 161,1.890288e-09, 162,1.977499e-09, 163,1.594781e-09, 164,1.781459e-09, 165,8.359718e-10, 166,1.450794e-09, 167,5.659607e-10, 168,1.916460e-09,
+ 169,1.656429e-09, 170,1.981433e-09, 171,1.984843e-09, 172,1.133462e-09, 173,1.594261e-09, 174,1.029623e-09, 175,5.741441e-10, 176,1.489961e-09,
+ 177,1.086768e-09, 178,1.377235e-09, 179,1.801507e-09, 180,1.194177e-09, 181,1.694406e-09, 182,1.435150e-09, 183,1.416349e-09, 184,1.775697e-09,
+ 185,8.905703e-10, 186,1.648756e-09, 187,1.441139e-09, 188,1.462191e-09, 189,1.632734e-09, 190,1.276976e-09, 191,1.210131e-09, 192,1.146281e-09,
+ 193,1.363810e-09, 194,5.286635e-10, 195,5.585015e-10, 196,5.027888e-10, 197,1.386463e-09, 198,7.072313e-10, 199,1.253563e-09, 200,5.167757e-10,
+ 201,9.292637e-10, 202,5.666059e-10, 203,1.968884e-09, 204,1.467262e-09, 205,1.337700e-09, 206,1.392383e-09, 207,1.699538e-09, 208,1.830569e-09,
+ 209,1.517451e-09, 210,1.600160e-09, 211,8.169421e-10, 212,9.129163e-10, 213,1.726267e-09, 214,5.666221e-10, 215,1.590466e-09, 216,1.915463e-09,
+ 217,9.906850e-10, 218,8.300300e-10, 219,1.815850e-09, 220,1.746510e-09, 221,1.082530e-09, 222,1.750744e-09, 223,1.571739e-09, 224,1.977141e-09,
+ 225,1.634246e-09, 226,6.155316e-10, 227,1.258324e-09, 228,6.570407e-10, 229,5.688925e-10, 230,1.555844e-09, 231,1.109935e-09, 232,1.617600e-09,
+ 233,1.069220e-09, 234,1.784508e-09, 235,9.785997e-10, 236,1.786185e-09, 237,9.994781e-10, 238,8.334686e-10, 239,1.443922e-09, 240,1.686325e-09,
+ 241,1.325534e-09, 242,1.551535e-09, 243,8.818183e-10, 244,7.403312e-10, 245,5.562255e-10, 246,9.028235e-10, 247,1.251730e-09, 248,1.249708e-09,
+ 249,8.592022e-10, 250,1.876348e-09, 251,1.236252e-09, 252,1.343285e-09)
.param K24=table(run, 1,1.500000e-02, 2,1.500000e-02, 3,8.072278e-03, 4,2.614184e-02, 5,1.255527e-02, 6,1.757538e-02, 7,1.809200e-02, 8,5.283777e-03,
+ 9,2.382570e-02, 10,3.073055e-03, 11,8.117414e-03, 12,1.427039e-03, 13,3.377882e-03, 14,1.408341e-02, 15,1.240668e-04, 16,2.226107e-02,
+ 17,2.968105e-02, 18,6.066390e-03, 19,3.049562e-03, 20,1.369281e-02, 21,2.798234e-02, 22,3.000076e-03, 23,2.800173e-02, 24,1.297844e-02,
+ 25,4.823003e-03, 26,1.811666e-02, 27,1.134921e-02, 28,7.147196e-03, 29,1.054142e-02, 30,2.712773e-02, 31,2.349432e-02, 32,1.305513e-02,
+ 33,1.762472e-02, 34,1.241892e-02, 35,1.395124e-02, 36,3.858082e-03, 37,6.873733e-03, 38,1.113022e-02, 39,1.162107e-02, 40,1.395365e-02,
+ 41,1.262811e-02, 42,6.177474e-03, 43,1.152885e-02, 44,8.289164e-03, 45,1.557985e-02, 46,2.592666e-02, 47,1.916302e-02, 48,4.932041e-03,
+ 49,1.508647e-02, 50,4.668831e-03, 51,9.652939e-03, 52,2.177949e-02, 53,1.072362e-02, 54,2.702425e-02, 55,7.131461e-03, 56,1.088349e-03,
+ 57,2.584177e-02, 58,1.596022e-02, 59,2.577754e-02, 60,4.813207e-03, 61,2.993613e-02, 62,2.401762e-02, 63,5.728204e-03, 64,1.332627e-03,
+ 65,2.604856e-02, 66,8.407728e-04, 67,3.791967e-03, 68,2.487803e-02, 69,2.015425e-02, 70,1.258180e-02, 71,1.559715e-02, 72,8.448583e-03,
+ 73,2.429209e-02, 74,2.436771e-02, 75,4.491695e-03, 76,1.116491e-02, 77,1.545651e-02, 78,5.009323e-03, 79,6.900138e-03, 80,2.282108e-02,
+ 81,1.949944e-03, 82,1.277537e-02, 83,1.794242e-02, 84,1.226373e-02, 85,7.720852e-03, 86,2.364901e-02, 87,7.765343e-03, 88,1.615498e-02,
+ 89,2.110035e-03, 90,1.658274e-02, 91,7.498814e-03, 92,2.312889e-02, 93,6.673682e-03, 94,5.333782e-04, 95,2.793943e-03, 96,2.835837e-02,
+ 97,2.945804e-02, 98,6.482685e-03, 99,4.909585e-04, 100,6.732525e-03, 101,7.344354e-03, 102,2.900198e-02, 103,1.808188e-02, 104,6.471775e-03,
+ 105,1.743111e-02, 106,2.923277e-02, 107,2.515843e-02, 108,2.624585e-02, 109,4.591726e-03, 110,2.918479e-02, 111,1.353886e-02, 112,1.192515e-02,
+ 113,2.564625e-02, 114,1.874944e-02, 115,2.347413e-02, 116,1.728900e-02, 117,2.451074e-02, 118,2.261883e-02, 119,2.098972e-02, 120,1.035817e-02,
+ 121,7.848225e-03, 122,2.292771e-02, 123,2.374144e-02, 124,1.133565e-02, 125,2.039838e-02, 126,8.126770e-04, 127,2.138933e-02, 128,1.567342e-03,
+ 129,1.856516e-02, 130,1.537618e-02, 131,1.327619e-02, 132,2.887829e-02, 133,9.381232e-03, 134,1.493828e-02, 135,1.544788e-02, 136,4.224773e-03,
+ 137,1.644290e-02, 138,1.727436e-02, 139,3.062581e-03, 140,1.935417e-02, 141,5.716946e-03, 142,2.659334e-02, 143,1.660788e-02, 144,2.693810e-02,
+ 145,4.594192e-03, 146,7.880664e-03, 147,2.798956e-02, 148,1.864963e-02, 149,9.072516e-03, 150,2.083387e-02, 151,2.971091e-02, 152,2.952317e-02,
+ 153,3.877316e-03, 154,7.208330e-03, 155,2.629228e-02, 156,2.005353e-02, 157,1.810783e-02, 158,1.229922e-03, 159,5.087275e-03, 160,1.966732e-02,
+ 161,1.411384e-02, 162,2.481359e-02, 163,1.671564e-02, 164,2.454639e-02, 165,4.827233e-03, 166,2.762344e-02, 167,3.119477e-03, 168,8.544068e-03,
+ 169,4.707866e-03, 170,1.853825e-02, 171,2.983348e-02, 172,1.487833e-03, 173,1.926903e-02, 174,1.075200e-02, 175,2.653924e-02, 176,1.152263e-02,
+ 177,7.873907e-03, 178,1.118879e-02, 179,1.399946e-02, 180,1.279333e-02, 181,1.350713e-02, 182,1.909619e-02, 183,2.165335e-02, 184,5.004574e-03,
+ 185,6.463742e-04, 186,2.628651e-02, 187,2.081269e-02, 188,1.131782e-03, 189,2.436967e-02, 190,5.371469e-03, 191,2.340092e-02, 192,7.056144e-03,
+ 193,2.818949e-02, 194,7.556018e-04, 195,6.572100e-03, 196,1.960890e-02, 197,1.040392e-02, 198,9.650823e-03, 199,7.510692e-03, 200,5.743395e-03,
+ 201,2.425277e-02, 202,2.685134e-02, 203,1.835641e-02, 204,8.373850e-03, 205,1.441898e-02, 206,2.885716e-02, 207,2.203677e-02, 208,6.315802e-03,
+ 209,5.540587e-03, 210,1.514887e-02, 211,1.686755e-02, 212,9.810974e-03, 213,2.323229e-02, 214,1.134720e-02, 215,6.805420e-03, 216,1.440928e-02,
+ 217,6.884830e-04, 218,2.948379e-02, 219,4.979011e-03, 220,2.597693e-02, 221,8.763885e-03, 222,2.431722e-02, 223,7.703348e-03, 224,1.962077e-02,
+ 225,6.260204e-03, 226,1.691045e-02, 227,2.024434e-02, 228,2.231457e-02, 229,1.737137e-02, 230,2.046051e-02, 231,8.264172e-04, 232,1.547701e-03,
+ 233,1.073116e-02, 234,1.371534e-02, 235,2.276450e-02, 236,2.123523e-02, 237,2.686796e-02, 238,1.164884e-02, 239,1.733232e-02, 240,1.899494e-02,
+ 241,8.678181e-04, 242,2.817075e-02, 243,6.070305e-03, 244,2.948961e-02, 245,3.259499e-03, 246,6.703308e-03, 247,2.510897e-02, 248,1.715173e-03,
+ 249,2.115750e-02, 250,2.771751e-02, 251,2.889377e-02, 252,1.004462e-02)
.param K46=table(run, 1,1.500000e-02, 2,1.500000e-02, 3,3.479491e-03, 4,8.473506e-03, 5,2.415459e-02, 6,4.392901e-03, 7,9.847334e-03, 8,1.710400e-02,
+ 9,2.196003e-02, 10,2.830567e-02, 11,3.628338e-03, 12,3.931158e-03, 13,5.972620e-03, 14,2.601040e-02, 15,1.098992e-02, 16,2.088411e-02,
+ 17,2.808608e-02, 18,3.259597e-03, 19,2.403810e-02, 20,2.120778e-02, 21,2.649521e-02, 22,2.995000e-02, 23,1.392054e-02, 24,4.086563e-03,
+ 25,2.304377e-02, 26,3.053476e-03, 27,1.659845e-02, 28,3.670626e-03, 29,1.519251e-03, 30,2.089262e-02, 31,1.230700e-02, 32,2.538704e-02,
+ 33,6.062262e-03, 34,2.084030e-02, 35,4.736086e-03, 36,1.910896e-02, 37,3.478795e-04, 38,1.803843e-02, 39,2.007242e-02, 40,3.963507e-04,
+ 41,2.023506e-02, 42,1.439188e-02, 43,2.440109e-02, 44,1.973539e-02, 45,2.165367e-03, 46,1.666362e-02, 47,1.119620e-02, 48,2.103842e-02,
+ 49,1.159109e-02, 50,1.355617e-02, 51,1.623059e-02, 52,1.832554e-02, 53,1.648650e-02, 54,1.334485e-02, 55,1.018487e-02, 56,2.912961e-02,
+ 57,1.840742e-02, 58,2.138179e-02, 59,2.456816e-03, 60,1.852331e-02, 61,1.541055e-02, 62,6.818108e-03, 63,1.983436e-02, 64,5.160302e-03,
+ 65,1.070453e-02, 66,1.506118e-02, 67,1.200658e-03, 68,7.925687e-03, 69,1.409199e-02, 70,6.897880e-03, 71,2.925143e-03, 72,2.372140e-02,
+ 73,2.692663e-02, 74,1.282336e-02, 75,1.418691e-02, 76,1.135657e-02, 77,2.329001e-02, 78,2.685715e-02, 79,2.505599e-02, 80,1.021276e-02,
+ 81,1.983747e-02, 82,2.853369e-02, 83,2.235223e-02, 84,2.019107e-02, 85,2.379406e-02, 86,1.625396e-02, 87,2.095359e-02, 88,2.247499e-02,
+ 89,2.745387e-02, 90,9.017666e-03, 91,2.576118e-02, 92,2.851880e-03, 93,8.621163e-04, 94,2.869723e-03, 95,1.887996e-02, 96,1.351305e-02,
+ 97,1.606799e-02, 98,4.982616e-03, 99,2.867658e-02, 100,5.959987e-03, 101,5.048196e-03, 102,2.603890e-02, 103,1.425248e-02, 104,2.197374e-02,
+ 105,2.645235e-02, 106,2.468848e-02, 107,2.407170e-02, 108,1.015839e-02, 109,3.099672e-03, 110,4.967210e-03, 111,7.072479e-03, 112,2.834869e-02,
+ 113,1.407035e-02, 114,1.822435e-02, 115,1.068994e-02, 116,2.443463e-02, 117,1.638338e-02, 118,2.414357e-02, 119,2.139927e-02, 120,1.966802e-02,
+ 121,2.381202e-02, 122,3.876269e-03, 123,8.180064e-03, 124,9.754880e-04, 125,8.586285e-04, 126,1.905144e-02, 127,9.687919e-03, 128,7.433402e-03,
+ 129,4.148362e-03, 130,2.589901e-02, 131,1.493687e-02, 132,9.632525e-03, 133,1.448631e-02, 134,1.950189e-02, 135,1.314458e-02, 136,2.373909e-02,
+ 137,2.334959e-02, 138,4.997269e-03, 139,2.328716e-02, 140,2.852545e-03, 141,1.015708e-02, 142,6.520070e-03, 143,1.712758e-02, 144,1.368685e-02,
+ 145,2.295469e-02, 146,2.299840e-03, 147,1.987822e-02, 148,7.727069e-03, 149,1.560211e-02, 150,1.915660e-02, 151,1.311302e-02, 152,2.866839e-02,
+ 153,5.489002e-03, 154,7.285378e-03, 155,2.878989e-03, 156,2.476054e-02, 157,4.561150e-03, 158,1.515166e-02, 159,2.656681e-02, 160,2.280383e-02,
+ 161,2.747485e-02, 162,2.832675e-02, 163,2.618745e-02, 164,1.001258e-02, 165,5.953604e-03, 166,1.719054e-02, 167,1.803356e-02, 168,7.427563e-03,
+ 169,2.542460e-02, 170,9.555079e-04, 171,2.517936e-02, 172,1.818305e-02, 173,2.303233e-03, 174,2.875633e-02, 175,2.614730e-02, 176,1.014230e-02,
+ 177,2.990817e-02, 178,2.433168e-02, 179,1.350138e-02, 180,2.433396e-02, 181,1.397748e-02, 182,2.633368e-02, 183,1.319630e-02, 184,5.484776e-03,
+ 185,2.221883e-03, 186,1.515671e-02, 187,1.835943e-02, 188,2.207657e-02, 189,1.109927e-02, 190,7.758185e-03, 191,8.781392e-03, 192,9.714003e-03,
+ 193,6.605510e-03, 194,1.800829e-02, 195,1.389340e-02, 196,4.337602e-03, 197,6.225169e-03, 198,1.770769e-02, 199,1.014711e-02, 200,3.972238e-03,
+ 201,6.316896e-03, 202,2.912024e-03, 203,2.126705e-02, 204,1.969030e-02, 205,2.048494e-02, 206,9.748340e-03, 207,1.854552e-02, 208,1.110899e-02,
+ 209,2.569672e-02, 210,1.020532e-02, 211,1.880395e-02, 212,1.059603e-02, 213,7.634503e-03, 214,1.829162e-02, 215,2.489568e-02, 216,1.163720e-02,
+ 217,2.334803e-02, 218,2.570006e-02, 219,1.420763e-02, 220,5.164981e-03, 221,4.316442e-03, 222,9.230953e-03, 223,2.592203e-03, 224,1.732037e-02,
+ 225,2.120840e-02, 226,6.413178e-03, 227,2.877402e-03, 228,2.170517e-02, 229,1.107740e-02, 230,3.422172e-03, 231,1.033059e-02, 232,9.446662e-03,
+ 233,8.506621e-03, 234,2.553095e-02, 235,1.727013e-02, 236,1.295250e-02, 237,3.428633e-03, 238,9.313333e-03, 239,1.007890e-02, 240,2.941217e-03,
+ 241,1.435918e-02, 242,2.263035e-02, 243,2.051836e-02, 244,1.270315e-03, 245,1.337919e-02, 246,1.368071e-02, 247,3.067477e-03, 248,1.583198e-02,
+ 249,2.322408e-02, 250,9.846752e-03, 251,2.528734e-02, 252,2.772788e-02)
.param K26=table(run, 1,2.000000e-03, 2,2.000000e-03, 3,5.068969e-04, 4,8.842020e-04, 5,2.871002e-03, 6,3.493544e-03, 7,4.279436e-04, 8,2.773277e-03,
+ 9,2.761693e-03, 10,6.737894e-04, 11,5.840050e-03, 12,2.459043e-03, 13,5.042488e-03, 14,7.243291e-04, 15,1.921804e-03, 16,1.201378e-03,
+ 17,5.874764e-04, 18,5.588479e-03, 19,3.880210e-03, 20,1.508245e-03, 21,1.181212e-03, 22,1.184094e-03, 23,1.291519e-03, 24,1.827559e-03,
+ 25,2.508798e-03, 26,2.964924e-03, 27,2.476132e-03, 28,1.545333e-03, 29,4.170937e-04, 30,2.376148e-03, 31,5.809072e-03, 32,5.976671e-03,
+ 33,4.805776e-03, 34,2.258419e-03, 35,4.421466e-03, 36,2.995198e-03, 37,5.707890e-03, 38,2.292651e-03, 39,1.745086e-03, 40,4.828781e-03,
+ 41,2.436817e-03, 42,3.698875e-03, 43,3.171521e-03, 44,2.359820e-03, 45,1.997940e-03, 46,5.537023e-03, 47,1.922234e-03, 48,3.718485e-03,
+ 49,2.599517e-04, 50,6.878306e-04, 51,4.787233e-03, 52,2.324756e-03, 53,4.991743e-03, 54,1.804604e-03, 55,4.517697e-03, 56,5.324427e-03,
+ 57,2.747416e-03, 58,8.205319e-04, 59,1.473721e-03, 60,4.862459e-03, 61,2.229356e-03, 62,3.991840e-03, 63,1.512404e-03, 64,2.201103e-03,
+ 65,5.786772e-03, 66,1.949915e-03, 67,2.661923e-03, 68,1.715016e-03, 69,4.119586e-03, 70,2.607907e-03, 71,2.818238e-03, 72,3.148213e-03,
+ 73,4.921817e-03, 74,5.911003e-03, 75,3.956704e-03, 76,3.493209e-03, 77,4.366827e-03, 78,5.120786e-03, 79,1.301288e-03, 80,4.613576e-04,
+ 81,3.117705e-03, 82,3.879726e-03, 83,4.009102e-03, 84,2.378057e-03, 85,5.610022e-03, 86,4.367289e-03, 87,5.080345e-03, 88,1.337273e-03,
+ 89,4.104790e-03, 90,1.007032e-03, 91,5.575232e-03, 92,5.009944e-03, 93,1.517041e-03, 94,5.197081e-03, 95,5.906921e-03, 96,3.733122e-03,
+ 97,1.031568e-03, 98,9.089193e-04, 99,2.869989e-03, 100,1.233529e-03, 101,1.340639e-03, 102,2.954637e-03, 103,3.140518e-03, 104,5.754208e-03,
+ 105,2.257372e-03, 106,1.978922e-03, 107,4.945797e-03, 108,3.992089e-03, 109,1.283553e-03, 110,5.891267e-03, 111,1.605034e-03, 112,2.655183e-03,
+ 113,4.968787e-03, 114,6.316178e-04, 115,2.338354e-03, 116,8.665836e-04, 117,4.042658e-04, 118,4.699543e-03, 119,2.976343e-03, 120,6.909452e-04,
+ 121,4.165493e-03, 122,1.238745e-03, 123,5.033636e-03, 124,4.172471e-03, 125,1.059261e-03, 126,5.356376e-03, 127,2.579644e-03, 128,4.055940e-03,
+ 129,5.571559e-03, 130,4.648914e-03, 131,5.922692e-04, 132,4.377918e-03, 133,3.614680e-03, 134,3.591761e-03, 135,2.093102e-03, 136,1.762097e-03,
+ 137,3.796664e-03, 138,3.443187e-03, 139,5.447981e-03, 140,2.463230e-03, 141,8.846843e-04, 142,2.426132e-03, 143,2.261711e-03, 144,5.865241e-03,
+ 145,9.234408e-04, 146,4.712226e-03, 147,4.179729e-04, 148,2.356329e-03, 149,2.545437e-03, 150,4.977180e-03, 151,3.708851e-03, 152,5.306040e-03,
+ 153,3.142535e-03, 154,2.518775e-03, 155,1.650480e-03, 156,2.462368e-03, 157,5.763921e-03, 158,1.889131e-03, 159,2.474364e-03, 160,6.689573e-04,
+ 161,2.846857e-03, 162,1.014326e-03, 163,1.264678e-03, 164,1.211652e-03, 165,1.902808e-03, 166,1.470596e-03, 167,5.363574e-03, 168,5.367681e-03,
+ 169,4.584190e-03, 170,3.975379e-03, 171,3.461189e-03, 172,5.762627e-03, 173,3.629751e-03, 174,3.014346e-03, 175,5.396848e-03, 176,1.416475e-03,
+ 177,7.180692e-04, 178,4.872812e-03, 179,2.134028e-03, 180,5.813337e-03, 181,5.040070e-03, 182,4.328921e-04, 183,2.223156e-03, 184,3.006973e-03,
+ 185,4.701999e-03, 186,1.920488e-03, 187,2.407480e-03, 188,4.867425e-03, 189,1.390224e-03, 190,3.966721e-03, 191,4.148762e-03, 192,5.487995e-04,
+ 193,1.329894e-03, 194,2.532331e-03, 195,4.545045e-03, 196,4.445510e-03, 197,1.151372e-03, 198,2.405582e-03, 199,2.316708e-03, 200,2.695924e-03,
+ 201,3.265251e-03, 202,3.452157e-03, 203,4.122899e-03, 204,5.011723e-03, 205,3.838767e-03, 206,2.455692e-03, 207,5.194109e-03, 208,2.218782e-03,
+ 209,2.935765e-03, 210,2.689366e-03, 211,4.657978e-03, 212,4.217072e-03, 213,2.994599e-03, 214,2.366933e-03, 215,5.134951e-03, 216,7.868796e-04,
+ 217,4.404657e-03, 218,2.026362e-03, 219,3.870014e-03, 220,5.802340e-03, 221,1.399155e-03, 222,4.606217e-03, 223,5.500415e-03, 224,3.231370e-03,
+ 225,4.137932e-03, 226,4.217518e-03, 227,3.968488e-03, 228,5.743170e-03, 229,2.953419e-03, 230,3.906544e-03, 231,3.215331e-03, 232,3.898672e-03,
+ 233,4.839210e-03, 234,3.486189e-03, 235,1.924492e-03, 236,3.586707e-03, 237,5.938263e-03, 238,4.637370e-03, 239,1.637663e-03, 240,5.163165e-03,
+ 241,2.376437e-03, 242,2.183347e-03, 243,4.762023e-03, 244,4.904876e-03, 245,4.977766e-03, 246,5.356705e-03, 247,5.022634e-03, 248,3.114286e-03,
+ 249,4.783615e-04, 250,1.539289e-03, 251,1.274592e-03, 252,7.217457e-04)
.param Cio=table(run, 1,2.000000e-15, 2,2.000000e-15, 3,4.128590e-15, 4,4.221672e-15, 5,2.347462e-15, 6,4.236735e-15, 7,5.660828e-16, 8,2.415155e-15,
+ 9,1.094626e-15, 10,7.124317e-16, 11,1.699734e-15, 12,3.187486e-15, 13,3.733519e-15, 14,3.500869e-15, 15,1.023539e-15, 16,8.320763e-16,
+ 17,3.328350e-15, 18,3.660206e-15, 19,7.035918e-16, 20,1.051305e-15, 21,3.528149e-15, 22,4.169804e-15, 23,2.340861e-15, 24,1.516293e-15,
+ 25,3.869025e-15, 26,9.050623e-16, 27,3.154135e-15, 28,4.180861e-15, 29,4.822558e-15, 30,3.717760e-15, 31,4.345629e-15, 32,1.460894e-15,
+ 33,1.210117e-15, 34,3.259915e-15, 35,4.496830e-15, 36,9.302180e-16, 37,7.246979e-16, 38,1.665642e-15, 39,1.131189e-15, 40,3.036152e-15,
+ 41,1.529134e-15, 42,4.659713e-15, 43,3.389231e-15, 44,4.886153e-15, 45,2.865776e-15, 46,1.380290e-15, 47,1.370130e-15, 48,4.976361e-15,
+ 49,4.612786e-15, 50,4.844937e-15, 51,4.717610e-15, 52,2.329020e-15, 53,1.829932e-15, 54,4.889722e-15, 55,2.138309e-15, 56,4.464534e-15,
+ 57,2.179617e-15, 58,1.020757e-15, 59,4.512219e-15, 60,4.090785e-15, 61,3.451781e-15, 62,4.570886e-15, 63,9.007873e-16, 64,1.374968e-15,
+ 65,2.266972e-15, 66,3.284547e-15, 67,3.013388e-15, 68,4.516229e-15, 69,8.946889e-16, 70,1.922513e-15, 71,3.715918e-15, 72,4.244042e-15,
+ 73,3.933557e-15, 74,3.721344e-15, 75,3.958011e-15, 76,1.027512e-15, 77,3.309494e-15, 78,4.576915e-15, 79,3.322728e-15, 80,4.312804e-15,
+ 81,2.198650e-15, 82,4.420104e-15, 83,2.753671e-15, 84,1.129771e-15, 85,1.110472e-15, 86,4.527330e-15, 87,2.377616e-15, 88,2.148835e-15,
+ 89,3.826208e-15, 90,3.967257e-15, 91,4.692456e-15, 92,1.614156e-15, 93,1.788711e-15, 94,2.563522e-15, 95,2.439167e-15, 96,3.187603e-15,
+ 97,3.220814e-15, 98,4.301084e-15, 99,3.506933e-15, 100,1.440790e-15, 101,1.802353e-15, 102,3.750340e-15, 103,4.588416e-15, 104,4.640196e-15,
+ 105,2.974971e-15, 106,2.219994e-15, 107,2.959544e-15, 108,3.131810e-15, 109,2.734639e-15, 110,2.597944e-15, 111,3.274601e-15, 112,1.284686e-15,
+ 113,2.145334e-15, 114,2.705756e-15, 115,2.866536e-15, 116,2.557328e-15, 117,4.002903e-15, 118,4.538932e-15, 119,3.865506e-15, 120,1.757522e-15,
+ 121,4.917135e-15, 122,1.897903e-15, 123,2.505417e-15, 124,4.371551e-15, 125,3.535843e-15, 126,1.266880e-15, 127,3.540812e-15, 128,2.983433e-15,
+ 129,4.842618e-15, 130,4.088069e-15, 131,1.018279e-15, 132,4.843856e-15, 133,1.156603e-15, 134,3.206285e-15, 135,2.863506e-15, 136,2.163791e-15,
+ 137,6.257033e-16, 138,1.606937e-15, 139,1.971990e-15, 140,1.181417e-15, 141,4.298923e-15, 142,1.068928e-15, 143,4.318891e-15, 144,4.041962e-15,
+ 145,3.660187e-15, 146,1.258615e-15, 147,3.901128e-15, 148,2.796276e-15, 149,4.612661e-15, 150,9.738384e-16, 151,1.957170e-15, 152,9.552059e-16,
+ 153,2.604923e-15, 154,2.690069e-15, 155,2.648102e-15, 156,8.529203e-16, 157,2.599778e-15, 158,1.145074e-15, 159,1.715665e-15, 160,2.557909e-15,
+ 161,2.854089e-15, 162,2.766376e-15, 163,4.089671e-15, 164,1.217924e-15, 165,1.562389e-15, 166,5.596049e-16, 167,4.963148e-15, 168,4.649218e-15,
+ 169,4.012185e-15, 170,3.580498e-15, 171,9.082214e-16, 172,4.420118e-15, 173,3.760001e-15, 174,4.683337e-15, 175,1.790360e-15, 176,3.489905e-15,
+ 177,1.280497e-15, 178,2.725577e-15, 179,3.999049e-15, 180,6.087153e-16, 181,4.672657e-15, 182,9.466936e-16, 183,1.091455e-15, 184,4.242649e-15,
+ 185,2.173082e-15, 186,1.101686e-15, 187,3.299401e-15, 188,3.040224e-15, 189,3.708666e-15, 190,4.778465e-15, 191,2.466899e-15, 192,1.190264e-15,
+ 193,1.465044e-15, 194,1.405999e-15, 195,4.128171e-15, 196,3.601804e-15, 197,4.984274e-15, 198,4.672288e-15, 199,1.284455e-15, 200,4.109627e-15,
+ 201,1.689601e-15, 202,3.944981e-15, 203,2.209991e-15, 204,8.656876e-16, 205,1.612704e-15, 206,1.390911e-15, 207,4.881924e-15, 208,4.110893e-15,
+ 209,4.812864e-15, 210,4.608784e-15, 211,4.852101e-15, 212,4.008159e-15, 213,2.856224e-15, 214,2.870135e-15, 215,1.853142e-15, 216,4.185174e-15,
+ 217,2.764836e-15, 218,2.637483e-15, 219,1.261365e-15, 220,6.547043e-16, 221,3.069372e-15, 222,2.847321e-15, 223,5.231206e-16, 224,3.912980e-15,
+ 225,2.832725e-15, 226,1.208071e-15, 227,1.629117e-15, 228,2.519762e-15, 229,4.333244e-15, 230,2.128755e-15, 231,4.790184e-15, 232,4.406195e-15,
+ 233,2.663362e-15, 234,3.705993e-15, 235,6.953608e-16, 236,3.993953e-15, 237,2.289235e-15, 238,2.818307e-15, 239,3.927392e-15, 240,1.048440e-15,
+ 241,4.357727e-15, 242,4.723404e-15, 243,4.455974e-15, 244,2.800702e-15, 245,3.237037e-15, 246,1.328376e-15, 247,3.898752e-15, 248,2.991484e-15,
+ 249,1.888647e-15, 250,1.375900e-15, 251,1.508043e-15, 252,3.907312e-15)
V_m src_m 0 AC 2
RS_m src_m in_m 50
RL_m out_m 0 50
CPC1_m in_m 0 {C1Cpad}
C1_m in_m C1x1_m {C1C}
RC1_m C1x1_m C1x2_m {C1ESR}
LEC1_m C1x2_m C1x3_m {C1ESL} Rser=0
LVC1_m C1x3_m 0 {C1Lvia} Rser=0
CPC3_m a1_m 0 {C3Cpad}
C3_m a1_m C3x1_m {C3C}
RC3_m C3x1_m C3x2_m {C3ESR}
LEC3_m C3x2_m C3x3_m {C3ESL} Rser=0
LVC3_m C3x3_m 0 {C3Lvia} Rser=0
CPC5_m a2_m 0 {C5Cpad}
C5_m a2_m C5x1_m {C5C}
RC5_m C5x1_m C5x2_m {C5ESR}
LEC5_m C5x2_m C5x3_m {C5ESL} Rser=0
LVC5_m C5x3_m 0 {C5Lvia} Rser=0
CPC7_m out_m 0 {C7Cpad}
C7_m out_m C7x1_m {C7C}
RC7_m C7x1_m C7x2_m {C7ESR}
LEC7_m C7x2_m C7x3_m {C7ESL} Rser=0
LVC7_m C7x3_m 0 {C7Lvia} Rser=0
LTaL2_m in_m L2y1_m {L2Ltr/2} Rser=0
L2_m L2y1_m L2y2_m {L2L} Rser=0
RL2_m L2y2_m L2y3_m {L2R}
CSL2_m L2y1_m L2y3_m {L2C}
LTbL2_m L2y3_m a1_m {L2Ltr/2} Rser=0
LTaL4_m a1_m L4y1_m {L4Ltr/2} Rser=0
L4_m L4y1_m L4y2_m {L4L} Rser=0
RL4_m L4y2_m L4y3_m {L4R}
CSL4_m L4y1_m L4y3_m {L4C}
LTbL4_m L4y3_m a2_m {L4Ltr/2} Rser=0
LTaL6_m a2_m L6y1_m {L6Ltr/2} Rser=0
L6_m L6y1_m L6y2_m {L6L} Rser=0
RL6_m L6y2_m L6y3_m {L6R}
CSL6_m L6y1_m L6y3_m {L6C}
LTbL6_m L6y3_m out_m {L6Ltr/2} Rser=0
K24_m L2_m L4_m {K24}
K46_m L4_m L6_m {K46}
K26_m L2_m L6_m {K26}
CIO_m in_m out_m {Cio}
.ac lin 800 2e6 1600e6
.save V(out_m) V(in_m)
.meas AC s21_146 FIND V(out_m) AT 146000000
.meas AC s21_148 FIND V(out_m) AT 148000000
.meas AC s21_288 FIND V(out_m) AT 288000000
.meas AC s21_432 FIND V(out_m) AT 432000000
.meas AC rl_146 FIND V(in_m)-1 AT 146e6
.meas AC rl_148 FIND V(in_m)-1 AT 148e6
.meas AC echo_L4 PARAM L4L
.end
