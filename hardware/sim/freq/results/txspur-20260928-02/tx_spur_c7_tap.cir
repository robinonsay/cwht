* tx_spur_c7_tap.cir: valid-clock check of the /8 prescaler tap on the Si5351 CLK1 net (change C7, review finding-2)
* Product: docs/design/analysis/spurs-ts012.md (revision 1); checker hardware/sim/freq/tx_spur_plan.py.
* Run only through tools/ltspice-batch.sh (ACC-LTSPICE-001).
*
* Question: with a series resistor Rser between the 100 pF tap capacitor and the 74LVC1G80 CP input, does the
* pin still cross VIH 2.0 V and VIL 0.8 V (Nexperia 74LVC1G80 Rev. 17, 12 Nov 2024, Table 7, VCC 2.7 to 3.6 V)
* at every corner? The checker also reads the high and low pulse widths at VM 1.5 V (Table 8: tW 2.5 ns min)
* and the input transition rate (Table 6: 10 ns/V max).
*
* Source and drive network as in hardware/sim/tx-pa (docs/design/analysis/pa-drive-ts012.md, run d2):
*  Si5351A CLK1 trapezoid Thevenin source with the DC removed, VDDO 3.2 / 3.3 / 3.4 V, 20-80 % edge 1.5 / 1.0 /
*  0.5 ns (0-100 % ramp = 20-80 % / 0.6), duty 0.45 / 0.50 / 0.50, behind 25 or 50 ohm; drive LPF input
*  18 pF C0G (ESR 0.1 ohm, ESL plus via 1 nH, est.), 82 nH 1812SMS class (Q 100, 0.21 pF, est.), 18 pF, into the
*  50 ohm pad input.
* Tap (C7): 100 pF C0G (ESR 0.1 ohm, 1 nH, est.) -> Rser -> CP pin. At the pin: CI 5 pF (Table 7, typ; no
*  maximum is given) plus 1 or 3 pF of pad and trace (ESTIMATE); bias 12 k to 3.3 V and 9.1 k to ground
*  (1.42 V, midway between VIL 0.8 V and VIH 2.0 V); a ground clamp diode (the LVC input has no diode to VCC).
* Corners flattened into one .step (idx), fastest first: source case (3), carrier 144 / 148 MHz (2),
*  source resistance 25 / 50 ohm (2), pad capacitance 1 / 3 pF (2), Rser 0 / 47 / 100 / 150 / 220 / 330 ohm (6).
* 3 us transient (the bias time constant is about 0.52 us), the last 100 ns saved.
.param idx=0
.step param idx 0 143 1
.param isrc=idx-3*floor(idx/3)
.param ifr=floor(idx/3)-2*floor(idx/6)
.param irs=floor(idx/6)-2*floor(idx/12)
.param icp=floor(idx/12)-2*floor(idx/24)
.param irser=floor(idx/24)
.param vddo=table(isrc,0,3.2,1,3.3,2,3.4)
.param tr=table(isrc,0,2.5e-9,1,1.6667e-9,2,0.83333e-9)
.param duty=table(isrc,0,0.45,1,0.5,2,0.5)
.param freq=table(ifr,0,144e6,1,148e6)
.param rsrc=table(irs,0,25,1,50)
.param cpad=table(icp,0,1e-12,1,3e-12)
.param rser=table(irser,0,0.001,1,47,2,100,3,150,4,220,5,330)
.param T=1/freq
.param ton=duty*T-tr
V1 vs 0 PULSE({-duty*vddo} {(1-duty)*vddo} 0 {tr} {tr} {ton} {T})
Rsrc vs clk {rsrc}
* drive LPF input and the pad (as in hardware/sim/tx-pa drive_a5.cir)
C1 clk 0 18p Rser=0.1 Lser=1n
L1 clk lpf 82n Rser=0.75 Cpar=0.21p
C2 lpf 0 18p Rser=0.1 Lser=1n
Rpad lpf 0 50
* C7 tap
Ct clk t1 100p Rser=0.1 Lser=1n
Rs t1 pin {rser}
Cin pin 0 5p
Cpd pin 0 {cpad}
Rb1 vcc pin 12k
Rb2 pin 0 9.1k
Vcc vcc 0 3.3
Dcl 0 pin DCL
.model DCL D(Is=1e-14 N=1.05 Rs=5)
.tran 0 3u 2.9u 20p
.options plotwinsize=0
.save V(pin) V(clk)
.end
