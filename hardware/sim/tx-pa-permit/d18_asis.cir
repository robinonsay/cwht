* d18_asis.cir: D-18 gate as TS-012 revision 7 draws it (74LVC1G10 NAND on 3.3 V driving the DMP3099L
* gate and the 2N7002 clamp gate directly); element and key-up with PA_EN asserted. Generated by d18_run.py
.step param CASE 1 36 1
.param VBUSX=table(CASE,1,4.75,2,4.75,3,4.75,4,4.75,5,4.75,6,4.75,7,4.75,8,4.75,9,4.75,10,4.75,11,4.75,12,4.75,13,5,14,5,15,5,16,5,17,5,18,5,19,5,20,5,21,5,22,5,23,5,24,5,25,5.25,26,5.25,27,5.25,28,5.25,29,5.25,30,5.25,31,5.25,32,5.25,33,5.25,34,5.25,35,5.25,36,5.25)
.param V33X=table(CASE,1,3,2,3,3,3,4,3,5,3.3,6,3.3,7,3.3,8,3.3,9,3.6,10,3.6,11,3.6,12,3.6,13,3,14,3,15,3,16,3,17,3.3,18,3.3,19,3.3,20,3.3,21,3.6,22,3.6,23,3.6,24,3.6,25,3,26,3,27,3,28,3,29,3.3,30,3.3,31,3.3,32,3.3,33,3.6,34,3.6,35,3.6,36,3.6)
.param VTOP=table(CASE,1,-0.73,2,-1,3,-1.55,4,-2.1,5,-0.73,6,-1,7,-1.55,8,-2.1,9,-0.73,10,-1,11,-1.55,12,-2.1,13,-0.73,14,-1,15,-1.55,16,-2.1,17,-0.73,18,-1,19,-1.55,20,-2.1,21,-0.73,22,-1,23,-1.55,24,-2.1,25,-0.73,26,-1,27,-1.55,28,-2.1,29,-0.73,30,-1,31,-1.55,32,-2.1,33,-0.73,34,-1,35,-1.55,36,-2.1)
.param BFX=100 LS=0 TPE=0.007 TRS=0.01 TFA=TRS+0.016 TKF=TFA+8.470269e-03+1m
.param IE9=120u RUOPEN=1m
.param ATOP=2.75/(0.653846*VBUSX)
* --- device models ---------------------------------------------------------------------------------
* DMP3099L (D: DS36081 Rev. 5-2): VGS(th) -1.0 to -2.1 V at -250 uA (stepped; hot estimate -0.73 V), RDS(on)
* 99 mohm max at -4.5 V, Ciss 563 pF, Crss 41 pF, RG 10.3 ohm. VDMOS fit: Kp 5.6 A/V^2 with Rd + Rs 25 mohm gives
* 99 mohm at -4.5 V with the -2.1 V threshold; sub-threshold slope 0.04 V (E, about 92 mV/decade).
.model DMP3099L VDMOS(pchan Vto={VTOP} Kp=5.6 Rd=20m Rs=5m Rg=10.3 Cgdmax=300p Cgdmin=41p Cgs=520p Cjo=100p Is=1e-12 Rb=20m ksubthres=0.04)
* 2N7002 clamp (D: Nexperia Rev. 7): VGS(th) 1.0 / 2.0 / 2.5 V, 2.75 V max at -55 C (used: worst for the clamp),
* RDS(on) 5.3 ohm max at 4.5 V; Ciss 50 pF max.
.model N2N7002 VDMOS(Vto=2.75 Kp=0.2 Rd=1.5 Rs=0.5 Rg=10 Cgdmax=10p Cgdmin=3.5p Cgs=40p Cjo=10p Is=1e-14 ksubthres=0.04)
* 2N3904: the widely published Fairchild/onsemi SPICE model; BF stepped 70 (hFE min at 1 mA) and 416 (model).
.model Q2N3904X NPN(IS=6.734f XTI=3 EG=1.11 VAF=74.03 BF={BFX} NE=1.259 ISE=6.734f IKF=66.78m XTB=1.5 BR=.7371 NC=2 ISC=0 IKR=0 RC=1 CJC=3.638p MJC=.3085 VJC=.75 FC=.5 CJE=4.493p MJE=.2593 VJE=.75 TR=239.5n TF=301.2p ITF=.4 VTF=4 XTF=2 RB=10)
* 74LVC1G11/74LVC1G10 output: 25 ohm while VCC > 1.2 V, high impedance below (IOFF partial power-down).
.model SWVCC SW(Ron=25 Roff=1e9 Vt=1.2 Vh=0.1)
.model SWQ SW(Ron=100 Roff=1e10 Vt=0.5 Vh=0.05)
* --- 5 V bus: LM2940-5 (E: 50 mohm and 5 uH for its loop, 22 uF output capacitor) -------------------------
BLDO ldo 0 V={VBUSX}
LLDO ldo busi 5u Rser=50m
CBUS busi 0 22u Rser=20m
RBUSM busi bus 1m
* F3 (spurs-ts012.md): ferrite bead and 22 uF, upstream of the P-FET (E: 0.2 ohm, 1 uH)
LB bus nb 1u Rser=0.2
CF3 nb 0 22u Rser=10m
V33 v33 0 {V33X}
BTK 0 tk I=(1)*((V33X*(time>0.008)*(time<TKF))-V(tk))/50
RTKPD tk 0 4.7k
ITKE9 0 tk {IE9}
BPE 0 pe I=(1)*((V33X*(time>TPE)*(time<0.06))-V(pe))/50
RPEPD pe 0 4.7k
IPEE9 0 pe {IE9}
* --- cutoff monostable output Q: LM393 open collector, 10 k pull-up to the 5 V bus --------------------
RQPU q v33 10k
BQC qc 0 V=0
SQ q 0 qc 0 SWQ
BU1 u1i 0 V=V(v33)*(1-1/(1+exp(-(V(tk)-if(V(v33)>2.7,1.4,0.5*V(v33)))/0.02))*1/(1+exp(-(V(pe)-if(V(v33)>2.7,1.4,0.5*V(v33)))/0.02))*1/(1+exp(-(V(q)-if(V(v33)>2.7,1.4,0.5*V(v33)))/0.02)))
SU1 u1i u1o v33 0 SWVCC
RU1O u1o y {RUOPEN}
* --- as drawn in TS-012 revision 7: NAND output straight to the P-FET gate and the clamp gate -----------
RG1 y gp 100
M1 tx5 gp nb nb DMP3099L
RG4 y nc 100
M4 vgg nc 0 0 N2N7002
* --- GVA-84+ supply node TX5 and the device (E: I = 0.058 A/V x (V - 3.14 V), soft-plus below) ---------
C5B tx5 0 100n Rser=10m
LCH tx5 gvaf 1u Rser=0.5
BGVA gvaf 0 I=0.058*0.05*ln(1+exp((V(gvaf)-3.14)/0.05))
* --- VGG node: error-amplifier output (MCP6002 on the 5 V bus) through the 0.654 divider -----------------
BOA oa 0 V=min(V(bus),max(0,V(bus)*if(LS>0.5,1,ATOP)*if(time<TRS,0,if(time<TRS+8.470269e-03,0.5-0.5*cos(pi*(time-TRS)/8.470269e-03),if(LS>0.5,1,if(time<TFA,1,if(time<TFA+8.470269e-03,0.5+0.5*cos(pi*(time-TFA)/8.470269e-03),0)))))))
RD1 oa vgg 2.7k
RD2 vgg 0 5.1k
CVG vgg 0 10n
.save V(tx5) V(gp) V(nb) V(bus) V(vgg) V(nc) V(y) V(tk) V(pe) V(q) V(v33) Id(M1)
.tran 0 0.065 0 20u
.options plotwinsize=0
.end
