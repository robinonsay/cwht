* d18_seq.cir: D-18 gate D18-2B, power-up orders, brown-outs, single-line and single-component faults.
* Generated by hardware/sim/tx-pa-permit/d18_run.py. The error amplifier is wound to the 5 V rail in every
* case (worst for the clamp). Cases: see result.json.
.step param CASE 1 13 1
.param VBUSX=5.0 V33X=3.3 VTOP=-0.73 BFX=70 IE9=120u LS=1 TRS=0 TFA=1 ATOP=1
.param RUOPEN=table(CASE,1,1m,2,1m,3,1m,4,1m,5,1m,6,1m,7,1m,8,1m,9,1e12,10,1m,11,1m,12,1m,13,1m)
.param RPU1V=table(CASE,1,10k,2,10k,3,10k,4,10k,5,10k,6,10k,7,10k,8,10k,9,10k,10,1e12,11,10k,12,10k,13,10k)
.param RPU2V=table(CASE,1,10k,2,10k,3,10k,4,10k,5,10k,6,10k,7,10k,8,10k,9,10k,10,10k,11,10k,12,1e12,13,10k)
.param RQ2SH=table(CASE,1,1e12,2,1e12,3,1e12,4,1e12,5,1e12,6,1e12,7,1e12,8,1e12,9,1e12,10,1e12,11,1,12,1e12,13,1e12)
.param RQ3SH=table(CASE,1,1e12,2,1e12,3,1e12,4,1e12,5,1e12,6,1e12,7,1e12,8,1e12,9,1e12,10,1e12,11,1e12,12,1e12,13,1)
* --- device models ---------------------------------------------------------------------------------
* DMP3099L (D: DS36081 Rev. 5-2): VGS(th) -1.0 to -2.1 V at -250 uA (stepped; hot estimate -0.73 V), RDS(on)
* 99 mohm max at -4.5 V, Ciss 563 pF, Crss 41 pF, RG 10.3 ohm. VDMOS fit: Kp 5.6 A/V^2 with Rd + Rs 25 mohm gives
* 99 mohm at -4.5 V with the -2.1 V threshold; sub-threshold slope 0.04 V (E, about 92 mV/decade).
.model DMP3099L VDMOS(pchan Vto={VTOP} Kp=5.6 Rd=20m Rs=5m Rg=10.3 Cgdmax=300p Cgdmin=41p Cgs=520p Cjo=100p Is=1e-12 Rb=20m ksubthres=0.04)
* 2N7002 clamp (D: Nexperia Rev. 7): VGS(th) 1.0 / 2.0 / 2.5 V, 2.75 V max at -55 C (used: worst for the clamp),
* RDS(on) 5.3 ohm max at 4.5 V; Ciss 50 pF max.
.model N2N7002 VDMOS(Vto=2.75 Kp=0.2 Rd=1.5 Rs=0.5 Rg=10 Cgdmax=10p Cgdmin=3.5p Cgs=40p Cjo=10p Is=1e-14 ksubthres=0.04)
* 2N3904: the widely published Fairchild/onsemi SPICE model; BF stepped 70 (hFE min at 1 mA) and 416 (model).
.model Q2N3904X NPN(IS=6.734f XTI=3 EG=1.11 VAF=74.03 BF={BFX} NE=1.259 ISE=6.734f IKF=66.78m XTB=1.5 BR=.7371 NC=2 ISC=0 IKR=0 RC=1 CJC=3.638p MJC=.3085 VJC=.75 FC=.5 CJE=4.493p MJE=.2593 VJE=.75 TR=239.5n TF=301.2p ITF=.4 VTF=4 XTF=2 RB=10)
* 74LVC1G11/74LVC1G10 output: 25 ohm while VCC > 1.2 V, high impedance below (IOFF partial power-down).
.model SWVCC SW(Ron=25 Roff=1e9 Vt=1.2 Vh=0.1)
.model SWQ SW(Ron=100 Roff=1e10 Vt=0.5 Vh=0.05)
* --- 5 V bus: LM2940-5 (E: 50 mohm and 5 uH for its loop, 22 uF output capacitor) -------------------------
BLDO ldo 0 V=VBUSX*if(CASE==1,table(time,0,0,0.001,0,0.0011,1)*1,if(CASE==2,table(time,0,0,0.008,0,0.0081,1)*1,if(CASE==3,table(time,0,1)*1,if(CASE==4,table(time,0,1,0.02,1,0.021,0)*1,if(CASE==5,table(time,0,1)*1,if(CASE==6,table(time,0,1)*1,if(CASE==7,table(time,0,1)*1,if(CASE==8,table(time,0,1)*1,if(CASE==9,table(time,0,1)*1,if(CASE==10,table(time,0,1)*1,if(CASE==11,table(time,0,1)*1,if(CASE==12,table(time,0,1)*1,if(CASE==13,table(time,0,1)*1,0)))))))))))))
LLDO ldo busi 5u Rser=50m
CBUS busi 0 22u Rser=20m
RBUSM busi bus 1m
* F3 (spurs-ts012.md): ferrite bead and 22 uF, upstream of the P-FET (E: 0.2 ohm, 1 uH)
LB bus nb 1u Rser=0.2
CF3 nb 0 22u Rser=10m
BV33 v33 0 V=V33X*if(CASE==1,table(time,0,0,0.006,0,0.007,1)*1,if(CASE==2,table(time,0,0,0.001,0,0.0011,1)*1,if(CASE==3,table(time,0,1,0.02,1,0.021,0)*1,if(CASE==4,table(time,0,1)*1,if(CASE==5,table(time,0,1)*1,if(CASE==6,table(time,0,1)*1,if(CASE==7,table(time,0,1)*1,if(CASE==8,table(time,0,1)*1,if(CASE==9,table(time,0,1)*1,if(CASE==10,table(time,0,1)*1,if(CASE==11,table(time,0,1)*1,if(CASE==12,table(time,0,1)*1,if(CASE==13,table(time,0,1)*1,0)))))))))))))
BTK 0 tk I=(if(CASE==1,table(time,0,0,0.012,0,0.012001,1)*1,if(CASE==2,table(time,0,0,0.003,0,0.003001,1)*1,if(CASE==3,table(time,0,1)*1,if(CASE==4,table(time,0,1)*1,if(CASE==5,table(time,0,1)*1,if(CASE==6,table(time,0,1)*1,if(CASE==7,table(time,0,1)*1,if(CASE==8,table(time,0,1)*1,if(CASE==9,table(time,0,1)*1,if(CASE==10,table(time,0,1)*1,if(CASE==11,table(time,0,1)*1,if(CASE==12,table(time,0,1)*1,if(CASE==13,table(time,0,1)*1,0))))))))))))))*((V(v33)*if(CASE==1,table(time,0,0,0.02,0,0.02000001,1,0.03,1,0.03000001,0)*1,if(CASE==2,table(time,0,0,0.02,0,0.02000001,1,0.03,1,0.03000001,0)*1,if(CASE==3,table(time,0,0,0.005,0,0.00500001,1)*1,if(CASE==4,table(time,0,0,0.005,0,0.00500001,1)*1,if(CASE==5,table(time,0,0,0.005,0,0.00500001,1)*1,if(CASE==6,table(time,0,0,0.005,0,0.00500001,1)*1,if(CASE==7,table(time,0,1)*1,if(CASE==8,table(time,0,0)*1,if(CASE==9,table(time,0,0,0.005,0,0.00500001,1)*1,if(CASE==10,table(time,0,0,0.005,0,0.00500001,1,0.02,1,0.02000001,0)*1,if(CASE==11,table(time,0,0)*1,if(CASE==12,table(time,0,0)*1,if(CASE==13,table(time,0,0)*1,0))))))))))))))-V(tk))/50
RTKPD tk 0 4.7k
ITKE9 0 tk {IE9}
BPE 0 pe I=(if(CASE==1,table(time,0,0,0.012,0,0.012001,1)*1,if(CASE==2,table(time,0,0,0.003,0,0.003001,1)*1,if(CASE==3,table(time,0,1)*1,if(CASE==4,table(time,0,1)*1,if(CASE==5,table(time,0,1)*1,if(CASE==6,table(time,0,1)*1,if(CASE==7,table(time,0,1)*1,if(CASE==8,table(time,0,1)*1,if(CASE==9,table(time,0,1)*1,if(CASE==10,table(time,0,1)*1,if(CASE==11,table(time,0,1)*1,if(CASE==12,table(time,0,1)*1,if(CASE==13,table(time,0,1)*1,0))))))))))))))*((V(v33)*if(CASE==1,table(time,0,0,0.0199,0,0.01990001,1)*1,if(CASE==2,table(time,0,0,0.0199,0,0.01990001,1)*1,if(CASE==3,table(time,0,0,0.0049,0,0.00490001,1)*1,if(CASE==4,table(time,0,0,0.0049,0,0.00490001,1)*1,if(CASE==5,table(time,0,0,0.0049,0,0.00490001,1)*1,if(CASE==6,table(time,0,0,0.0049,0,0.00490001,1,0.02,1,0.02000001,0)*1,if(CASE==7,table(time,0,0)*1,if(CASE==8,table(time,0,1)*1,if(CASE==9,table(time,0,0,0.0049,0,0.00490001,1)*1,if(CASE==10,table(time,0,0,0.0049,0,0.00490001,1)*1,if(CASE==11,table(time,0,0)*1,if(CASE==12,table(time,0,0)*1,if(CASE==13,table(time,0,0)*1,0))))))))))))))-V(pe))/50
RPEPD pe 0 4.7k
IPEE9 0 pe {IE9}
* --- cutoff monostable output Q: LM393 open collector, 10 k pull-up to the 5 V bus --------------------
RQPU q bus 10k
BQC qc 0 V=if(CASE==1,0,if(CASE==2,0,if(CASE==3,0,if(CASE==4,0,if(CASE==5,(time>20m),if(CASE==6,0,if(CASE==7,0,if(CASE==8,0,if(CASE==9,0,if(CASE==10,0,if(CASE==11,0,if(CASE==12,0,if(CASE==13,0,0)))))))))))))
SQ q 0 qc 0 SWQ
BU1 u1i 0 V=V(v33)*1/(1+exp(-(V(tk)-if(V(v33)>2.7,1.4,0.5*V(v33)))/0.02))*1/(1+exp(-(V(pe)-if(V(v33)>2.7,1.4,0.5*V(v33)))/0.02))*1/(1+exp(-(V(q)-if(V(v33)>2.7,1.4,0.5*V(v33)))/0.02))
SU1 u1i u1o v33 0 SWVCC
RU1O u1o y {RUOPEN}
* --- D18-2B level interface --------------------------------------------------------------------------
* branch P: U1 -> 10 k -> Q2 base (100 k to ground); Q2 collector -> 1 k -> P-FET gate; 10 k gate to source
RB1 y b1 10k
RBE1 b1 0 100k
Q2 c1 b1 0 Q2N3904X
RQ2F c1 0 {RQ2SH}
RG1 c1 gp 1k
RPU1 gp nb {RPU1V}
M1 tx5 gp nb nb DMP3099L
RBL tx5 0 2.2k
* branch C: U1 -> 10 k -> Q3 base (100 k to ground); Q3 collector = clamp gate, 10 k to the 5 V bus
RB2 y b2 10k
RBE2 b2 0 100k
Q3 nc b2 0 Q2N3904X
RQ3F nc 0 {RQ3SH}
RPU2 nc bus {RPU2V}
M4 vgg nc 0 0 N2N7002
* --- GVA-84+ supply node TX5 and the device (E: I = 0.058 A/V x (V - 3.14 V), soft-plus below) ---------
C5B tx5 0 100n Rser=10m
LCH tx5 gvaf 1u Rser=0.5
BGVA gvaf 0 I=0.058*0.05*ln(1+exp((V(gvaf)-3.14)/0.05))
* --- VGG node: error-amplifier output (MCP6002 on the 5 V bus) through the 0.654 divider -----------------
BOA oa 0 V=min(V(bus),max(0,V(bus)*if(LS>0.5,1,ATOP)*1))
RD1 oa vgg 2.7k
RD2 vgg 0 5.1k
CVG vgg 0 10n
.save V(tx5) V(gp) V(nb) V(bus) V(vgg) V(nc) V(y) V(tk) V(pe) V(q) V(v33) Id(M1)
.tran 0 0.04 0 20u
.options plotwinsize=0
.end
