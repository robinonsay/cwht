* d18_keyup.cir: D-18 gate D18-2B, A5 key-up case with PA_EN asserted and CLK1 running (REQ-TX-014)
* generated by hardware/sim/tx-pa-permit/d18_run.py; one element (5 ms setting), key-up window to 60 ms,
* PA_EN cleared at 60 ms (end of the over). Cases: see result.json.
.step param CASE 1 52 1
.param VBUSX=table(CASE,1,4.75,2,4.75,3,4.75,4,4.75,5,4.75,6,4.75,7,4.75,8,4.75,9,4.75,10,4.75,11,4.75,12,4.75,13,4.75,14,4.75,15,4.75,16,4.75,17,4.75,18,4.75,19,4.75,20,4.75,21,4.75,22,4.75,23,4.75,24,4.75,25,5.25,26,5.25,27,5.25,28,5.25,29,5.25,30,5.25,31,5.25,32,5.25,33,5.25,34,5.25,35,5.25,36,5.25,37,5.25,38,5.25,39,5.25,40,5.25,41,5.25,42,5.25,43,5.25,44,5.25,45,5.25,46,5.25,47,5.25,48,5.25,49,4.75,50,4.75,51,5.25,52,5.25)
.param V33X=table(CASE,1,3,2,3,3,3,4,3,5,3,6,3,7,3,8,3,9,3,10,3,11,3,12,3,13,3.6,14,3.6,15,3.6,16,3.6,17,3.6,18,3.6,19,3.6,20,3.6,21,3.6,22,3.6,23,3.6,24,3.6,25,3,26,3,27,3,28,3,29,3,30,3,31,3,32,3,33,3,34,3,35,3,36,3,37,3.6,38,3.6,39,3.6,40,3.6,41,3.6,42,3.6,43,3.6,44,3.6,45,3.6,46,3.6,47,3.6,48,3.6,49,3,50,3,51,3,52,3)
.param VGPX=table(CASE,1,2.62,2,2.62,3,2.62,4,2.62,5,2.62,6,2.62,7,2.62,8,2.62,9,2.62,10,2.62,11,2.62,12,2.62,13,3.6,14,3.6,15,3.6,16,3.6,17,3.6,18,3.6,19,3.6,20,3.6,21,3.6,22,3.6,23,3.6,24,3.6,25,2.62,26,2.62,27,2.62,28,2.62,29,2.62,30,2.62,31,2.62,32,2.62,33,2.62,34,2.62,35,2.62,36,2.62,37,3.6,38,3.6,39,3.6,40,3.6,41,3.6,42,3.6,43,3.6,44,3.6,45,3.6,46,3.6,47,3.6,48,3.6,49,2.62,50,2.62,51,2.62,52,2.62)
.param VTOP=table(CASE,1,-0.73,2,-0.73,3,-0.73,4,-0.73,5,-1,6,-1,7,-1,8,-1,9,-2.1,10,-2.1,11,-2.1,12,-2.1,13,-0.73,14,-0.73,15,-0.73,16,-0.73,17,-1,18,-1,19,-1,20,-1,21,-2.1,22,-2.1,23,-2.1,24,-2.1,25,-0.73,26,-0.73,27,-0.73,28,-0.73,29,-1,30,-1,31,-1,32,-1,33,-2.1,34,-2.1,35,-2.1,36,-2.1,37,-0.73,38,-0.73,39,-0.73,40,-0.73,41,-1,42,-1,43,-1,44,-1,45,-2.1,46,-2.1,47,-2.1,48,-2.1,49,-0.73,50,-2.1,51,-0.73,52,-2.1)
.param BFX=table(CASE,1,70,2,70,3,416,4,416,5,70,6,70,7,416,8,416,9,70,10,70,11,416,12,416,13,70,14,70,15,416,16,416,17,70,18,70,19,416,20,416,21,70,22,70,23,416,24,416,25,70,26,70,27,416,28,416,29,70,30,70,31,416,32,416,33,70,34,70,35,416,36,416,37,70,38,70,39,416,40,416,41,70,42,70,43,416,44,416,45,70,46,70,47,416,48,416,49,70,50,70,51,70,52,70)
.param LS=table(CASE,1,0,2,1,3,0,4,1,5,0,6,1,7,0,8,1,9,0,10,1,11,0,12,1,13,0,14,1,15,0,16,1,17,0,18,1,19,0,20,1,21,0,22,1,23,0,24,1,25,0,26,1,27,0,28,1,29,0,30,1,31,0,32,1,33,0,34,1,35,0,36,1,37,0,38,1,39,0,40,1,41,0,42,1,43,0,44,1,45,0,46,1,47,0,48,1,49,0,50,0,51,0,52,0)
.param FB=table(CASE,1,0,2,0,3,0,4,0,5,0,6,0,7,0,8,0,9,0,10,0,11,0,12,0,13,0,14,0,15,0,16,0,17,0,18,0,19,0,20,0,21,0,22,0,23,0,24,0,25,0,26,0,27,0,28,0,29,0,30,0,31,0,32,0,33,0,34,0,35,0,36,0,37,0,38,0,39,0,40,0,41,0,42,0,43,0,44,0,45,0,46,0,47,0,48,0,49,1,50,1,51,1,52,1)
.param TPE=if(FB>0.5,0.011,0.007) TRS=if(FB>0.5,0.0115,0.01)
.param TFA=TRS+0.016 TKF=TFA+8.470269e-03+1m
.param IE9=120u RUOPEN=1m RQ2SH=1e12 RQ3SH=1e12 RPU1V=10k RPU2V=10k RD1SER=1m RU1STK=1e12
.param ATOP=2.75/(0.653846*VBUSX)
* --- device models ---------------------------------------------------------------------------------
* DMP3099L (D: DS36081 Rev. 5-2): VGS(th) -1.0 to -2.1 V at -250 uA (stepped; hot estimate -0.73 V), RDS(on)
* 99 mohm max at -4.5 V, Ciss 563 pF, Crss 41 pF, RG 10.3 ohm. VDMOS fit: Kp 5.6 A/V^2 with Rd + Rs 25 mohm gives
* 99 mohm at -4.5 V with the -2.1 V threshold; sub-threshold slope 0.04 V (E, about 92 mV/decade).
.model DMP3099L VDMOS(pchan Vto={VTOP} Kp=5.6 Rd=20m Rs=5m Rg=10.3 Cgdmax=300p Cgdmin=41p Cgs=520p Cjo=100p Is=1e-12 Rb=20m ksubthres=0.04)
* 2N7002 clamp (D: Nexperia Rev. 7): VGS(th) 1.0 / 2.0 / 2.5 V, 2.75 V max at -55 C (used: worst for the clamp),
* RDS(on) 5.3 ohm max at 4.5 V; Ciss 50 pF max.
.model N2N7002 VDMOS(Vto=2.75 Kp=0.2 Rd=1.5 Rs=0.5 Rg=10 Cgdmax=10p Cgdmin=3.5p Cgs=40p Cjo=10p Is=1e-14 ksubthres=0.04)
* 2N3904: the widely published Fairchild/onsemi SPICE model; BF stepped 70 (hFE min at 1 mA) and 416 (model).
.model Q2N3904X NPN(IS=6.734f XTI=3 EG=1.11 VAF=74.03 BF={BFX} NE=1.259 ISE=6.734f IKF=66.78m XTB=1.5 BR=.7371 NC=2 ISC=0 IKR=0 RC=1 CJC=3.638p MJC=.3085 VJC=.75 FC=.5 CJE=4.493p MJE=.2593 VJE=.75 TR=239.5n TF=301.2p ITF=.4 VTF=4 XTF=2 RB=10)
* 74LVC1G11/74LVC1G10 output: 25 ohm while VCC > 1.2 V, high impedance below (IOFF partial power-down).
.model SWVCC SW(Ron=25 Roff=1e9 Vt=1.2 Vh=0.1)
.model SWQ SW(Ron=100 Roff=1e10 Vt=0.5 Vh=0.05)
* revision 1: LM393 cutoff output at its VOL maximum (switch to a 0.7 V source), VBUS inhibit open drain (5.3 ohm)
.model SWK SW(Ron=1 Roff=1e10 Vt=0.5 Vh=0.05)
.model SWB SW(Ron=5.3 Roff=1e10 Vt=0.5 Vh=0.05)
* 1N5711W (D: Diodes DS11015 Rev. 15-2): fit through VF max 0.41 V at 1 mA and 1.00 V at 15 mA (maximum-VF model)
.model D1N5711W D(Is=1.07n N=1.05 Rs=36.9 Cjo=2p BV=70 Ibv=10u)
* --- 5 V bus: LM2940-5 (E: 50 mohm and 5 uH for its loop, 22 uF output capacitor) -------------------------
BLDO ldo 0 V={VBUSX}
LLDO ldo busi 5u Rser=50m
CBUS busi 0 22u Rser=20m
RBUSM busi bus 1m
* F3 (spurs-ts012.md): ferrite bead and 22 uF, upstream of the P-FET (E: 0.2 ohm, 1 uH)
LB bus nb 1u Rser=0.2
CF3 nb 0 22u Rser=10m
V33 v33 0 {V33X}
BTK 0 tk I=(1)*((VGPX*(time>0.008)*(time<TKF))-V(tk))/50
RTKPD tk 0 4.7k
ITKE9 0 tk {IE9}
BPE 0 pe I=(1)*((VGPX*(time>TPE)*(time<0.06))-V(pe))/50
RPEPD pe 0 4.7k
IPEE9 0 pe {IE9}
* --- cutoff monostable output Q: LM393 open collector, 10 k pull-up to the 5 V bus --------------------
RQPU q bus 10k
BQC qc 0 V=0
SQ q 0 qc 0 SWQ
BU1 u1i 0 V=V(v33)*1/(1+exp(-(V(tk)-if(V(v33)>2.7,1.4,0.5*V(v33)))/0.02))*1/(1+exp(-(V(pe)-if(V(v33)>2.7,1.4,0.5*V(v33)))/0.02))*1/(1+exp(-(V(q)-if(V(v33)>2.7,1.4,0.5*V(v33)))/0.02))
SU1 u1i u1o v33 0 SWVCC
RU1O u1o y {RUOPEN}
* --- D18-2B level interface --------------------------------------------------------------------------
* branch P: U1 -> 10 k -> Q2 base (100 k to ground); Q2 collector -> 1 k -> P-FET gate; 10 k gate to source
RB1 y b1 10k
RBE1 b1 0 100k
Q2 c1 b1 0 Q2N3904X
RQ2F c1 0 {RQ2SH}
RG1 c1 gp 1k
RPU1 gp nb {RPU1V}
M1 tx5 gp nb nb DMP3099L
RBL tx5 0 2.2k
* branch C: U1 -> 10 k -> Q3 base (100 k to ground); Q3 collector = clamp gate, 10 k to the 5 V bus
RB2 y b2 10k
RBE2 b2 0 100k
Q3 nc b2 0 Q2N3904X
RQ3F nc 0 {RQ3SH}
RPU2 nc bus {RPU2V}
M4 vgg nc 0 0 N2N7002
* --- revision 1: cutoffs on the Q node, D1 VGG -> Q, fault hooks ------------------------------------------
VOLX volx 0 0.7
BCQ cq 0 V=0
SCQ q volx cq 0 SWK
BCB cb 0 V=0
SCB q 0 cb 0 SWB
BCV cv 0 V=0
SCV vgg volx cv 0 SWK
D1 vgg d1k D1N5711W
RD1S d1k q {RD1SER}
RSTK y v33 {RU1STK}
* --- GVA-84+ supply node TX5 and the device (E: I = 0.058 A/V x (V - 3.14 V), soft-plus below) ---------
C5B tx5 0 100n Rser=10m
LCH tx5 gvaf 1u Rser=0.5
BGVA gvaf 0 I=0.058*0.05*ln(1+exp((V(gvaf)-3.14)/0.05))
* --- VGG node: error-amplifier output (MCP6002 on the 5 V bus) through the 0.654 divider -----------------
BOA oa 0 V=min(V(bus),max(0,V(bus)*if(LS>0.5,1,ATOP)*if(time<TRS,0,if(time<TRS+8.470269e-03,0.5-0.5*cos(pi*(time-TRS)/8.470269e-03),if(LS>0.5,1,if(time<TFA,1,if(time<TFA+8.470269e-03,0.5+0.5*cos(pi*(time-TFA)/8.470269e-03),0)))))))
RD1 oa vgg 2.7k
RD2 vgg 0 5.1k
CVG vgg 0 10n
.save V(tx5) V(gp) V(nb) V(bus) V(vgg) V(nc) V(y) V(tk) V(pe) V(q) V(v33) Id(M1) I(D1)
.tran 0 0.065 0 20u
.options plotwinsize=0
.end
