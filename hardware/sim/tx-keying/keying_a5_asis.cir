* keying_a5_asis.cir: keying envelope loop, TS-012 finalist A5 (RA07M1317M module, VGG loop), as written in TS-012 revision 4
* cwht WP-PDR-22 pre-order item; generated by hardware/sim/tx-keying/keying_run.py; record
* docs/design/analysis/keying-ts012.md. Envelope-domain behavioural deck (no RF carrier).
* Steps: for each corner in turn, the packs [6.4, 8.4] V (drain [5.5, 7.9] V),
* within each the power steps [5.0] W, within each the 3, 5, 8 ms (10-90 %) settings:
*   runs 1..6: PA curve shifted +0.000 V, error-amplifier offset +0.0 mV
* 50 WPM continuous dits: key down 24 ms, up 24 ms; relay command at key-down of element 1,
* contact closed at 7.5 ms; CLK1 and GVA-84+ bias on at 8 ms; ramp start 10 ms after each key-down;
* drive gated off 1 ms after each ramp end; VGG and integrator clamps applied at the gate.
.param TPER=0.048 TDIT=0.024 TLEAD=0.01 TCLK=0.008 TC=0.0075 TQ=3.2768e-05 TG=0.001
.param run=1
.param TSET=table(run,1,0.003,2,0.005,3,0.008,4,0.003,5,0.005,6,0.008)
.param TR={TSET/0.590334}
.param TE={TLEAD+TDIT+TR}
.param SCALE=table(run,1,0.606107,2,0.606107,3,0.606107,4,1.17985,5,1.17985,6,1.17985)
.param VSH=table(run,1,0,2,0,3,0,4,0,5,0,6,0)
.param VOS=table(run,1,0,2,0,3,0,4,0,5,0,6,0)
.param ASET=table(run,1,22.3607,2,22.3607,3,22.3607,4,22.3607,5,22.3607,6,22.3607)
.param VSET=table(run,1,1.2501,2,1.2501,3,1.2501,4,1.2501,5,1.2501,6,1.2501)
.param DB=table(run,1,1,2,1,3,1,4,1,5,1,6,1)
.param PLEAK=1.99526e-05
.param LOSS=0.891251 KDIV=0.654 KTRIM=0.1 KFF=1.0
.step param run 1 6 1
.func tm(x) {x-TPER*floor(x/TPER)}
.func rc(u) {if(u<TLEAD,0,if(u<TLEAD+TR,0.5*(1-cos(pi*(u-TLEAD)/TR)),if(u<TLEAD+TDIT,1,if(u<TE,0.5*(1+cos(pi*(u-TLEAD-TDIT)/TR)),0))))}
.func env(x) {rc(tm(floor(x/TQ)*TQ))}
.func wnd(u,a,b) {(u>=a)*(u<b)}
.func onw(x,a,b) {max(wnd(tm(x),a,b),(x>=TPER)*wnd(tm(x)+TPER,a,b))}
V5 v5 0 5
* firmware reference: raised-cosine table x VSET, 12-bit PWM updated every 32.768 us, 2-pole RC
Bref refraw 0 V=VSET*env(time)
R1 refraw r1 4.7k
C1 r1 0 10n
R2 r1 vref 4.7k
C2 vref 0 10n
* error amplifier as TS-012 describes it (MCP6002 half on the 5 V bus): inverting integrator,
* reference on the non-inverting input, idle-bias resistor from +5 V on the inverting input
XU1 vref inn out v5 OPA
Rin detf inn 10000
Cf inn out 1.6e-08
Ridle v5 inn 4.7e+06
* VGG node: divider Thevenin (0.654 = 5.1k/(2.7k+5.1k), 1.77 k), 10 nF
Bvt vt 0 V=KDIV*V(out)
Rth vt vgg 1770
Cg vgg 0 1e-08
* clamps (open collector, on at reset): VGG node held low and integrator parked outside the window
* ramp start .. drive gate
Bpk park 0 V=1-onw(time,TLEAD,TE+TG)
S1 vgg 0 park 0 SWC
S2 out inn park 0 SWC
S4 vref 0 park 0 SWC
.model SWC SW(Ron=10 Roff=1e9 Vt=0.5 Vh=0.05)
* PA static transfer (dBm at the reference drain voltage) scaled for the drain voltage, curve shifted
* by VSH (module-to-module threshold corner)
Bpg pg 0 V=SCALE*pow(10,(table(V(vgg)-VSH,-0.68,-279.485,-0.18,-229.485,0.32,-179.485,0.82,-129.485,1.32,-79.4846,1.82,-29.4846,2.32,20.5154,2.34,21.9368,2.36,23.1848,2.38,24.3838,2.4,25.5509,2.42,26.5753,2.44,27.58,2.46,28.5058,2.48,29.3797,2.5,30.0903,2.52,30.8095,2.54,31.2759,2.56,32.1018,2.58,32.7779,2.6,33.4682,2.62,33.9358,2.64,34.4373,2.66,34.8966,2.68,35.3405,2.7,35.7068,2.72,36.1383,2.74,36.4895,2.76,36.7686,2.78,36.9978,2.8,37.2139,2.82,37.4003,2.84,37.5709,2.86,37.734,2.88,37.8522,2.9,38.0028,2.92,38.1122,2.94,38.2265,2.96,38.3248,2.98,38.4164,3,38.4956,3.02,38.5763,3.04,38.6442,3.06,38.7051,3.08,38.7593,3.1,38.8036,3.12,38.8485,3.14,38.8856,3.16,38.9215,3.18,38.9492,3.2,38.9787,3.22,39.0097,3.24,39.0316,3.26,39.0528,3.28,39.0656,3.3,39.0856,3.32,39.1049,3.34,39.1242,3.36,39.1415,3.38,39.1548,3.4,39.1693,3.5,39.242,3.6,39.3215,3.7,39.4076,3.8,39.4905,3.9,39.5716)-30)/10)
* drive gate: CLK1 enable and GVA-84+ bias, 10 us
Bd dr0 0 V=onw(time,TCLK,TE+TG)
Rd dr0 dr 1k
Cd dr 0 10n
* relay pole A contact (closes 7.5 ms after the relay command)
Bc cont 0 V=time>TC
* power and amplitude at the 50 ohm load (after 0.5 dB LPF and relay loss); PLEAK is the output with
* the gate off and the exciter driven (estimate, see the record)
Bpl pl 0 V=V(cont)*V(dr)*(V(pg)+PLEAK)*LOSS
Bal al 0 V=sqrt(100*max(V(pl),0))
* detector static law from run 2026-09-28-det-char and its 22 us video pole (47 k, 470 pF)
Bdet d0 0 V=table(V(al),-1,0,0,0,0.05,4.87137e-06,0.1,1.95321e-05,0.2,7.88445e-05,0.35,0.000247494,0.6,0.000779085,1,0.00256097,1.7,0.0106159,3,0.0494128,5,0.146371,9,0.380622,15,0.760293,22.36,1.24208,28,1.61703)
Rv d0 detf 1k
Cv detf 0 22n
* op-amp macro: gm stage, Aol 112 dB, GBW 1 MHz, internal node and output limited to the rails
.subckt OPA inp inn out vcc
G1 0 x inp inn 1m
Rx x 0 4e8
Cx x 0 159p
Dhi x vcc DI
Dlo 0 x DI
Bo o 0 V=limit(V(x),0.015,V(vcc)-0.015)
Ro o out 20
.model DI D(Ron=1 Roff=1e12 Vfwd=0)
.ends OPA
.save V(al) V(vgg) V(vref) V(detf)
.tran 0 0.384 0.0 20u
.options reltol=1e-4
.end
