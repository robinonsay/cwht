* keying_a5_sens.cir: keying envelope loop, TS-012 finalist A5 (RA07M1317M module, VGG loop), revision 1 design, element 1 only, VSH sweep in 0.02 V for the offset, pack and sub-threshold slope cases
* cwht WP-PDR-22 pre-order item; generated by hardware/sim/tx-keying/keying_run.py; record
* docs/design/analysis/keying-ts012.md. Envelope-domain behavioural deck (no RF carrier).
* Steps: for each corner in turn, the packs [7.4] V (drain [6.7] V),
* within each the power steps [0.5, 1.0, 2.0, 5.0] W, within each the 3, 5, 8 ms (10-90 %) settings:
* (variant sens: for each case in turn, VSH -0.30 to +0.30 V in 0.02 V, within each
* the steps and settings; the pack of the case; element 1 only)
*   runs 1..372: nominal: pack 7.4 V, offset +0.0 mV, PA sub-threshold slope 100 dB/V
*   runs 373..744: VOS +1 mV: pack 7.4 V, offset +1.0 mV, PA sub-threshold slope 100 dB/V
*   runs 745..1116: VOS -1 mV: pack 7.4 V, offset -1.0 mV, PA sub-threshold slope 100 dB/V
*   runs 1117..1488: pack 6.4 V: pack 6.4 V, offset +0.0 mV, PA sub-threshold slope 100 dB/V
*   runs 1489..1860: pack 8.4 V: pack 8.4 V, offset +0.0 mV, PA sub-threshold slope 100 dB/V
*   runs 1861..2232: slope 65 dB/V: pack 7.4 V, offset +0.0 mV, PA sub-threshold slope 65 dB/V
*   runs 2233..2604: slope 150 dB/V: pack 7.4 V, offset +0.0 mV, PA sub-threshold slope 150 dB/V
* 50 WPM continuous dits: key down 24 ms, up 24 ms; relay command at key-down of element 1,
* contact closed at 7.5 ms; CLK1 and GVA-84+ bias on at 8 ms; ramp start 10 ms after each key-down;
* drive gated off 1 ms after each ramp end; VGG and integrator clamps applied at the gate.
.param TPER=0.048 TDIT=0.024 TLEAD=0.01 TCLK=0.008 TC=0.0075 TQ=3.2768e-05 TG=0.001
.param run=1
.param TSET=table(run,1,0.003,2,0.005,3,0.008,4,0.003,5,0.005,6,0.008,7,0.003,8,0.005,9,0.008,10,0.003,11,0.005,12,0.008,13,0.003,14,0.005,15,0.008,16,0.003,17,0.005,18,0.008,19,0.003,20,0.005,21,0.008,22,0.003,23,0.005,24,0.008,25,0.003,26,0.005,27,0.008,28,0.003,29,0.005,30,0.008,31,0.003,32,0.005,33,0.008,34,0.003,35,0.005,36,0.008,37,0.003,38,0.005,39,0.008,40,0.003,41,0.005,42,0.008,43,0.003,44,0.005,45,0.008,46,0.003,47,0.005,48,0.008,49,0.003,50,0.005,51,0.008,52,0.003,53,0.005,54,0.008,55,0.003,56,0.005,57,0.008,58,0.003,59,0.005,60,0.008,61,0.003,62,0.005,63,0.008,64,0.003,65,0.005,66,0.008,67,0.003,68,0.005,69,0.008,70,0.003,71,0.005,72,0.008,73,0.003,74,0.005,75,0.008,76,0.003,77,0.005,78,0.008,79,0.003,80,0.005,81,0.008,82,0.003,83,0.005,84,0.008,85,0.003,86,0.005,87,0.008,88,0.003,89,0.005,90,0.008,91,0.003,92,0.005,93,0.008,94,0.003,95,0.005,96,0.008,97,0.003,98,0.005,99,0.008,100,0.003,101,0.005,102,0.008,103,0.003,104,0.005,105,0.008,106,0.003,107,0.005,108,0.008,109,0.003,110,0.005,111,0.008,112,0.003,113,0.005,114,0.008,115,0.003,116,0.005,117,0.008,118,0.003,119,0.005,120,0.008,121,0.003,122,0.005,123,0.008,124,0.003,125,0.005,126,0.008,127,0.003,128,0.005,129,0.008,130,0.003,131,0.005,132,0.008,133,0.003,134,0.005,135,0.008,136,0.003,137,0.005,138,0.008,139,0.003,140,0.005,141,0.008,142,0.003,143,0.005,144,0.008,145,0.003,146,0.005,147,0.008,148,0.003,149,0.005,150,0.008,151,0.003,152,0.005,153,0.008,154,0.003,155,0.005,156,0.008,157,0.003,158,0.005,159,0.008,160,0.003,161,0.005,162,0.008,163,0.003,164,0.005,165,0.008,166,0.003,167,0.005,168,0.008,169,0.003,170,0.005,171,0.008,172,0.003,173,0.005,174,0.008,175,0.003,176,0.005,177,0.008,178,0.003,179,0.005,180,0.008,181,0.003,182,0.005,183,0.008,184,0.003,185,0.005,186,0.008,187,0.003,188,0.005,189,0.008,190,0.003,191,0.005,192,0.008,193,0.003,194,0.005,195,0.008,196,0.003,197,0.005,198,0.008,199,0.003,200,0.005,201,0.008,202,0.003,203,0.005,204,0.008,205,0.003,206,0.005,207,0.008,208,0.003,209,0.005,210,0.008,211,0.003,212,0.005,213,0.008,214,0.003,215,0.005,216,0.008,217,0.003,218,0.005,219,0.008,220,0.003,221,0.005,222,0.008,223,0.003,224,0.005,225,0.008,226,0.003,227,0.005,228,0.008,229,0.003,230,0.005,231,0.008,232,0.003,233,0.005,234,0.008,235,0.003,236,0.005,237,0.008,238,0.003,239,0.005,240,0.008,241,0.003,242,0.005,243,0.008,244,0.003,245,0.005,246,0.008,247,0.003,248,0.005,249,0.008,250,0.003,251,0.005,252,0.008,253,0.003,254,0.005,255,0.008,256,0.003,257,0.005,258,0.008,259,0.003,260,0.005,261,0.008,262,0.003,263,0.005,264,0.008,265,0.003,266,0.005,267,0.008,268,0.003,269,0.005,270,0.008,271,0.003,272,0.005,273,0.008,274,0.003,275,0.005,276,0.008,277,0.003,278,0.005,279,0.008,280,0.003,281,0.005,282,0.008,283,0.003,284,0.005,285,0.008,286,0.003,287,0.005,288,0.008,289,0.003,290,0.005,291,0.008,292,0.003,293,0.005,294,0.008,295,0.003,296,0.005,297,0.008,298,0.003,299,0.005,300,0.008,301,0.003,302,0.005,303,0.008,304,0.003,305,0.005,306,0.008,307,0.003,308,0.005,309,0.008,310,0.003,311,0.005,312,0.008,313,0.003,314,0.005,315,0.008,316,0.003,317,0.005,318,0.008,319,0.003,320,0.005,321,0.008,322,0.003,323,0.005,324,0.008,325,0.003,326,0.005,327,0.008,328,0.003,329,0.005,330,0.008,331,0.003,332,0.005,333,0.008,334,0.003,335,0.005,336,0.008,337,0.003,338,0.005,339,0.008,340,0.003,341,0.005,342,0.008,343,0.003,344,0.005,345,0.008,346,0.003,347,0.005,348,0.008,349,0.003,350,0.005,351,0.008,352,0.003,353,0.005,354,0.008,355,0.003,356,0.005,357,0.008,358,0.003,359,0.005,360,0.008,361,0.003,362,0.005,363,0.008,364,0.003,365,0.005,366,0.008,367,0.003,368,0.005,369,0.008,370,0.003,371,0.005,372,0.008,373,0.003,374,0.005,375,0.008,376,0.003,377,0.005,378,0.008,379,0.003,380,0.005,381,0.008,382,0.003,383,0.005,384,0.008,385,0.003,386,0.005,387,0.008,388,0.003,389,0.005,390,0.008,391,0.003,392,0.005,393,0.008,394,0.003,395,0.005,396,0.008,397,0.003,398,0.005,399,0.008,400,0.003,401,0.005,402,0.008,403,0.003,404,0.005,405,0.008,406,0.003,407,0.005,408,0.008,409,0.003,410,0.005,411,0.008,412,0.003,413,0.005,414,0.008,415,0.003,416,0.005,417,0.008,418,0.003,419,0.005,420,0.008,421,0.003,422,0.005,423,0.008,424,0.003,425,0.005,426,0.008,427,0.003,428,0.005,429,0.008,430,0.003,431,0.005,432,0.008,433,0.003,434,0.005,435,0.008,436,0.003,437,0.005,438,0.008,439,0.003,440,0.005,441,0.008,442,0.003,443,0.005,444,0.008,445,0.003,446,0.005,447,0.008,448,0.003,449,0.005,450,0.008,451,0.003,452,0.005,453,0.008,454,0.003,455,0.005,456,0.008,457,0.003,458,0.005,459,0.008,460,0.003,461,0.005,462,0.008,463,0.003,464,0.005,465,0.008,466,0.003,467,0.005,468,0.008,469,0.003,470,0.005,471,0.008,472,0.003,473,0.005,474,0.008,475,0.003,476,0.005,477,0.008,478,0.003,479,0.005,480,0.008,481,0.003,482,0.005,483,0.008,484,0.003,485,0.005,486,0.008,487,0.003,488,0.005,489,0.008,490,0.003,491,0.005,492,0.008,493,0.003,494,0.005,495,0.008,496,0.003,497,0.005,498,0.008,499,0.003,500,0.005,501,0.008,502,0.003,503,0.005,504,0.008,505,0.003,506,0.005,507,0.008,508,0.003,509,0.005,510,0.008,511,0.003,512,0.005,513,0.008,514,0.003,515,0.005,516,0.008,517,0.003,518,0.005,519,0.008,520,0.003,521,0.005,522,0.008,523,0.003,524,0.005,525,0.008,526,0.003,527,0.005,528,0.008,529,0.003,530,0.005,531,0.008,532,0.003,533,0.005,534,0.008,535,0.003,536,0.005,537,0.008,538,0.003,539,0.005,540,0.008,541,0.003,542,0.005,543,0.008,544,0.003,545,0.005,546,0.008,547,0.003,548,0.005,549,0.008,550,0.003,551,0.005,552,0.008,553,0.003,554,0.005,555,0.008,556,0.003,557,0.005,558,0.008,559,0.003,560,0.005,561,0.008,562,0.003,563,0.005,564,0.008,565,0.003,566,0.005,567,0.008,568,0.003,569,0.005,570,0.008,571,0.003,572,0.005,573,0.008,574,0.003,575,0.005,576,0.008,577,0.003,578,0.005,579,0.008,580,0.003,581,0.005,582,0.008,583,0.003,584,0.005,585,0.008,586,0.003,587,0.005,588,0.008,589,0.003,590,0.005,591,0.008,592,0.003,593,0.005,594,0.008,595,0.003,596,0.005,597,0.008,598,0.003,599,0.005,600,0.008,601,0.003,602,0.005,603,0.008,604,0.003,605,0.005,606,0.008,607,0.003,608,0.005,609,0.008,610,0.003,611,0.005,612,0.008,613,0.003,614,0.005,615,0.008,616,0.003,617,0.005,618,0.008,619,0.003,620,0.005,621,0.008,622,0.003,623,0.005,624,0.008,625,0.003,626,0.005,627,0.008,628,0.003,629,0.005,630,0.008,631,0.003,632,0.005,633,0.008,634,0.003,635,0.005,636,0.008,637,0.003,638,0.005,639,0.008,640,0.003,641,0.005,642,0.008,643,0.003,644,0.005,645,0.008,646,0.003,647,0.005,648,0.008,649,0.003,650,0.005,651,0.008,652,0.003,653,0.005,654,0.008,655,0.003,656,0.005,657,0.008,658,0.003,659,0.005,660,0.008,661,0.003,662,0.005,663,0.008,664,0.003,665,0.005,666,0.008,667,0.003,668,0.005,669,0.008,670,0.003,671,0.005,672,0.008,673,0.003,674,0.005,675,0.008,676,0.003,677,0.005,678,0.008,679,0.003,680,0.005,681,0.008,682,0.003,683,0.005,684,0.008,685,0.003,686,0.005,687,0.008,688,0.003,689,0.005,690,0.008,691,0.003,692,0.005,693,0.008,694,0.003,695,0.005,696,0.008,697,0.003,698,0.005,699,0.008,700,0.003,701,0.005,702,0.008,703,0.003,704,0.005,705,0.008,706,0.003,707,0.005,708,0.008,709,0.003,710,0.005,711,0.008,712,0.003,713,0.005,714,0.008,715,0.003,716,0.005,717,0.008,718,0.003,719,0.005,720,0.008,721,0.003,722,0.005,723,0.008,724,0.003,725,0.005,726,0.008,727,0.003,728,0.005,729,0.008,730,0.003,731,0.005,732,0.008,733,0.003,734,0.005,735,0.008,736,0.003,737,0.005,738,0.008,739,0.003,740,0.005,741,0.008,742,0.003,743,0.005,744,0.008,745,0.003,746,0.005,747,0.008,748,0.003,749,0.005,750,0.008,751,0.003,752,0.005,753,0.008,754,0.003,755,0.005,756,0.008,757,0.003,758,0.005,759,0.008,760,0.003,761,0.005,762,0.008,763,0.003,764,0.005,765,0.008,766,0.003,767,0.005,768,0.008,769,0.003,770,0.005,771,0.008,772,0.003,773,0.005,774,0.008,775,0.003,776,0.005,777,0.008,778,0.003,779,0.005,780,0.008,781,0.003,782,0.005,783,0.008,784,0.003,785,0.005,786,0.008,787,0.003,788,0.005,789,0.008,790,0.003,791,0.005,792,0.008,793,0.003,794,0.005,795,0.008,796,0.003,797,0.005,798,0.008,799,0.003,800,0.005,801,0.008,802,0.003,803,0.005,804,0.008,805,0.003,806,0.005,807,0.008,808,0.003,809,0.005,810,0.008,811,0.003,812,0.005,813,0.008,814,0.003,815,0.005,816,0.008,817,0.003,818,0.005,819,0.008,820,0.003,821,0.005,822,0.008,823,0.003,824,0.005,825,0.008,826,0.003,827,0.005,828,0.008,829,0.003,830,0.005,831,0.008,832,0.003,833,0.005,834,0.008,835,0.003,836,0.005,837,0.008,838,0.003,839,0.005,840,0.008,841,0.003,842,0.005,843,0.008,844,0.003,845,0.005,846,0.008,847,0.003,848,0.005,849,0.008,850,0.003,851,0.005,852,0.008,853,0.003,854,0.005,855,0.008,856,0.003,857,0.005,858,0.008,859,0.003,860,0.005,861,0.008,862,0.003,863,0.005,864,0.008,865,0.003,866,0.005,867,0.008,868,0.003,869,0.005,870,0.008,871,0.003,872,0.005,873,0.008,874,0.003,875,0.005,876,0.008,877,0.003,878,0.005,879,0.008,880,0.003,881,0.005,882,0.008,883,0.003,884,0.005,885,0.008,886,0.003,887,0.005,888,0.008,889,0.003,890,0.005,891,0.008,892,0.003,893,0.005,894,0.008,895,0.003,896,0.005,897,0.008,898,0.003,899,0.005,900,0.008,901,0.003,902,0.005,903,0.008,904,0.003,905,0.005,906,0.008,907,0.003,908,0.005,909,0.008,910,0.003,911,0.005,912,0.008,913,0.003,914,0.005,915,0.008,916,0.003,917,0.005,918,0.008,919,0.003,920,0.005,921,0.008,922,0.003,923,0.005,924,0.008,925,0.003,926,0.005,927,0.008,928,0.003,929,0.005,930,0.008,931,0.003,932,0.005,933,0.008,934,0.003,935,0.005,936,0.008,937,0.003,938,0.005,939,0.008,940,0.003,941,0.005,942,0.008,943,0.003,944,0.005,945,0.008,946,0.003,947,0.005,948,0.008,949,0.003,950,0.005,951,0.008,952,0.003,953,0.005,954,0.008,955,0.003,956,0.005,957,0.008,958,0.003,959,0.005,960,0.008,961,0.003,962,0.005,963,0.008,964,0.003,965,0.005,966,0.008,967,0.003,968,0.005,969,0.008,970,0.003,971,0.005,972,0.008,973,0.003,974,0.005,975,0.008,976,0.003,977,0.005,978,0.008,979,0.003,980,0.005,981,0.008,982,0.003,983,0.005,984,0.008,985,0.003,986,0.005,987,0.008,988,0.003,989,0.005,990,0.008,991,0.003,992,0.005,993,0.008,994,0.003,995,0.005,996,0.008,997,0.003,998,0.005,999,0.008,1000,0.003,1001,0.005,1002,0.008,1003,0.003,1004,0.005,1005,0.008,1006,0.003,1007,0.005,1008,0.008,1009,0.003,1010,0.005,1011,0.008,1012,0.003,1013,0.005,1014,0.008,1015,0.003,1016,0.005,1017,0.008,1018,0.003,1019,0.005,1020,0.008,1021,0.003,1022,0.005,1023,0.008,1024,0.003,1025,0.005,1026,0.008,1027,0.003,1028,0.005,1029,0.008,1030,0.003,1031,0.005,1032,0.008,1033,0.003,1034,0.005,1035,0.008,1036,0.003,1037,0.005,1038,0.008,1039,0.003,1040,0.005,1041,0.008,1042,0.003,1043,0.005,1044,0.008,1045,0.003,1046,0.005,1047,0.008,1048,0.003,1049,0.005,1050,0.008,1051,0.003,1052,0.005,1053,0.008,1054,0.003,1055,0.005,1056,0.008,1057,0.003,1058,0.005,1059,0.008,1060,0.003,1061,0.005,1062,0.008,1063,0.003,1064,0.005,1065,0.008,1066,0.003,1067,0.005,1068,0.008,1069,0.003,1070,0.005,1071,0.008,1072,0.003,1073,0.005,1074,0.008,1075,0.003,1076,0.005,1077,0.008,1078,0.003,1079,0.005,1080,0.008,1081,0.003,1082,0.005,1083,0.008,1084,0.003,1085,0.005,1086,0.008,1087,0.003,1088,0.005,1089,0.008,1090,0.003,1091,0.005,1092,0.008,1093,0.003,1094,0.005,1095,0.008,1096,0.003,1097,0.005,1098,0.008,1099,0.003,1100,0.005,1101,0.008,1102,0.003,1103,0.005,1104,0.008,1105,0.003,1106,0.005,1107,0.008,1108,0.003,1109,0.005,1110,0.008,1111,0.003,1112,0.005,1113,0.008,1114,0.003,1115,0.005,1116,0.008,1117,0.003,1118,0.005,1119,0.008,1120,0.003,1121,0.005,1122,0.008,1123,0.003,1124,0.005,1125,0.008,1126,0.003,1127,0.005,1128,0.008,1129,0.003,1130,0.005,1131,0.008,1132,0.003,1133,0.005,1134,0.008,1135,0.003,1136,0.005,1137,0.008,1138,0.003,1139,0.005,1140,0.008,1141,0.003,1142,0.005,1143,0.008,1144,0.003,1145,0.005,1146,0.008,1147,0.003,1148,0.005,1149,0.008,1150,0.003,1151,0.005,1152,0.008,1153,0.003,1154,0.005,1155,0.008,1156,0.003,1157,0.005,1158,0.008,1159,0.003,1160,0.005,1161,0.008,1162,0.003,1163,0.005,1164,0.008,1165,0.003,1166,0.005,1167,0.008,1168,0.003,1169,0.005,1170,0.008,1171,0.003,1172,0.005,1173,0.008,1174,0.003,1175,0.005,1176,0.008,1177,0.003,1178,0.005,1179,0.008,1180,0.003,1181,0.005,1182,0.008,1183,0.003,1184,0.005,1185,0.008,1186,0.003,1187,0.005,1188,0.008,1189,0.003,1190,0.005,1191,0.008,1192,0.003,1193,0.005,1194,0.008,1195,0.003,1196,0.005,1197,0.008,1198,0.003,1199,0.005,1200,0.008,1201,0.003,1202,0.005,1203,0.008,1204,0.003,1205,0.005,1206,0.008,1207,0.003,1208,0.005,1209,0.008,1210,0.003,1211,0.005,1212,0.008,1213,0.003,1214,0.005,1215,0.008,1216,0.003,1217,0.005,1218,0.008,1219,0.003,1220,0.005,1221,0.008,1222,0.003,1223,0.005,1224,0.008,1225,0.003,1226,0.005,1227,0.008,1228,0.003,1229,0.005,1230,0.008,1231,0.003,1232,0.005,1233,0.008,1234,0.003,1235,0.005,1236,0.008,1237,0.003,1238,0.005,1239,0.008,1240,0.003,1241,0.005,1242,0.008,1243,0.003,1244,0.005,1245,0.008,1246,0.003,1247,0.005,1248,0.008,1249,0.003,1250,0.005,1251,0.008,1252,0.003,1253,0.005,1254,0.008,1255,0.003,1256,0.005,1257,0.008,1258,0.003,1259,0.005,1260,0.008,1261,0.003,1262,0.005,1263,0.008,1264,0.003,1265,0.005,1266,0.008,1267,0.003,1268,0.005,1269,0.008,1270,0.003,1271,0.005,1272,0.008,1273,0.003,1274,0.005,1275,0.008,1276,0.003,1277,0.005,1278,0.008,1279,0.003,1280,0.005,1281,0.008,1282,0.003,1283,0.005,1284,0.008,1285,0.003,1286,0.005,1287,0.008,1288,0.003,1289,0.005,1290,0.008,1291,0.003,1292,0.005,1293,0.008,1294,0.003,1295,0.005,1296,0.008,1297,0.003,1298,0.005,1299,0.008,1300,0.003,1301,0.005,1302,0.008,1303,0.003,1304,0.005,1305,0.008,1306,0.003,1307,0.005,1308,0.008,1309,0.003,1310,0.005,1311,0.008,1312,0.003,1313,0.005,1314,0.008,1315,0.003,1316,0.005,1317,0.008,1318,0.003,1319,0.005,1320,0.008,1321,0.003,1322,0.005,1323,0.008,1324,0.003,1325,0.005,1326,0.008,1327,0.003,1328,0.005,1329,0.008,1330,0.003,1331,0.005,1332,0.008,1333,0.003,1334,0.005,1335,0.008,1336,0.003,1337,0.005,1338,0.008,1339,0.003,1340,0.005,1341,0.008,1342,0.003,1343,0.005,1344,0.008,1345,0.003,1346,0.005,1347,0.008,1348,0.003,1349,0.005,1350,0.008,1351,0.003,1352,0.005,1353,0.008,1354,0.003,1355,0.005,1356,0.008,1357,0.003,1358,0.005,1359,0.008,1360,0.003,1361,0.005,1362,0.008,1363,0.003,1364,0.005,1365,0.008,1366,0.003,1367,0.005,1368,0.008,1369,0.003,1370,0.005,1371,0.008,1372,0.003,1373,0.005,1374,0.008,1375,0.003,1376,0.005,1377,0.008,1378,0.003,1379,0.005,1380,0.008,1381,0.003,1382,0.005,1383,0.008,1384,0.003,1385,0.005,1386,0.008,1387,0.003,1388,0.005,1389,0.008,1390,0.003,1391,0.005,1392,0.008,1393,0.003,1394,0.005,1395,0.008,1396,0.003,1397,0.005,1398,0.008,1399,0.003,1400,0.005,1401,0.008,1402,0.003,1403,0.005,1404,0.008,1405,0.003,1406,0.005,1407,0.008,1408,0.003,1409,0.005,1410,0.008,1411,0.003,1412,0.005,1413,0.008,1414,0.003,1415,0.005,1416,0.008,1417,0.003,1418,0.005,1419,0.008,1420,0.003,1421,0.005,1422,0.008,1423,0.003,1424,0.005,1425,0.008,1426,0.003,1427,0.005,1428,0.008,1429,0.003,1430,0.005,1431,0.008,1432,0.003,1433,0.005,1434,0.008,1435,0.003,1436,0.005,1437,0.008,1438,0.003,1439,0.005,1440,0.008,1441,0.003,1442,0.005,1443,0.008,1444,0.003,1445,0.005,1446,0.008,1447,0.003,1448,0.005,1449,0.008,1450,0.003,1451,0.005,1452,0.008,1453,0.003,1454,0.005,1455,0.008,1456,0.003,1457,0.005,1458,0.008,1459,0.003,1460,0.005,1461,0.008,1462,0.003,1463,0.005,1464,0.008,1465,0.003,1466,0.005,1467,0.008,1468,0.003,1469,0.005,1470,0.008,1471,0.003,1472,0.005,1473,0.008,1474,0.003,1475,0.005,1476,0.008,1477,0.003,1478,0.005,1479,0.008,1480,0.003,1481,0.005,1482,0.008,1483,0.003,1484,0.005,1485,0.008,1486,0.003,1487,0.005,1488,0.008,1489,0.003,1490,0.005,1491,0.008,1492,0.003,1493,0.005,1494,0.008,1495,0.003,1496,0.005,1497,0.008,1498,0.003,1499,0.005,1500,0.008,1501,0.003,1502,0.005,1503,0.008,1504,0.003,1505,0.005,1506,0.008,1507,0.003,1508,0.005,1509,0.008,1510,0.003,1511,0.005,1512,0.008,1513,0.003,1514,0.005,1515,0.008,1516,0.003,1517,0.005,1518,0.008,1519,0.003,1520,0.005,1521,0.008,1522,0.003,1523,0.005,1524,0.008,1525,0.003,1526,0.005,1527,0.008,1528,0.003,1529,0.005,1530,0.008,1531,0.003,1532,0.005,1533,0.008,1534,0.003,1535,0.005,1536,0.008,1537,0.003,1538,0.005,1539,0.008,1540,0.003,1541,0.005,1542,0.008,1543,0.003,1544,0.005,1545,0.008,1546,0.003,1547,0.005,1548,0.008,1549,0.003,1550,0.005,1551,0.008,1552,0.003,1553,0.005,1554,0.008,1555,0.003,1556,0.005,1557,0.008,1558,0.003,1559,0.005,1560,0.008,1561,0.003,1562,0.005,1563,0.008,1564,0.003,1565,0.005,1566,0.008,1567,0.003,1568,0.005,1569,0.008,1570,0.003,1571,0.005,1572,0.008,1573,0.003,1574,0.005,1575,0.008,1576,0.003,1577,0.005,1578,0.008,1579,0.003,1580,0.005,1581,0.008,1582,0.003,1583,0.005,1584,0.008,1585,0.003,1586,0.005,1587,0.008,1588,0.003,1589,0.005,1590,0.008,1591,0.003,1592,0.005,1593,0.008,1594,0.003,1595,0.005,1596,0.008,1597,0.003,1598,0.005,1599,0.008,1600,0.003,1601,0.005,1602,0.008,1603,0.003,1604,0.005,1605,0.008,1606,0.003,1607,0.005,1608,0.008,1609,0.003,1610,0.005,1611,0.008,1612,0.003,1613,0.005,1614,0.008,1615,0.003,1616,0.005,1617,0.008,1618,0.003,1619,0.005,1620,0.008,1621,0.003,1622,0.005,1623,0.008,1624,0.003,1625,0.005,1626,0.008,1627,0.003,1628,0.005,1629,0.008,1630,0.003,1631,0.005,1632,0.008,1633,0.003,1634,0.005,1635,0.008,1636,0.003,1637,0.005,1638,0.008,1639,0.003,1640,0.005,1641,0.008,1642,0.003,1643,0.005,1644,0.008,1645,0.003,1646,0.005,1647,0.008,1648,0.003,1649,0.005,1650,0.008,1651,0.003,1652,0.005,1653,0.008,1654,0.003,1655,0.005,1656,0.008,1657,0.003,1658,0.005,1659,0.008,1660,0.003,1661,0.005,1662,0.008,1663,0.003,1664,0.005,1665,0.008,1666,0.003,1667,0.005,1668,0.008,1669,0.003,1670,0.005,1671,0.008,1672,0.003,1673,0.005,1674,0.008,1675,0.003,1676,0.005,1677,0.008,1678,0.003,1679,0.005,1680,0.008,1681,0.003,1682,0.005,1683,0.008,1684,0.003,1685,0.005,1686,0.008,1687,0.003,1688,0.005,1689,0.008,1690,0.003,1691,0.005,1692,0.008,1693,0.003,1694,0.005,1695,0.008,1696,0.003,1697,0.005,1698,0.008,1699,0.003,1700,0.005,1701,0.008,1702,0.003,1703,0.005,1704,0.008,1705,0.003,1706,0.005,1707,0.008,1708,0.003,1709,0.005,1710,0.008,1711,0.003,1712,0.005,1713,0.008,1714,0.003,1715,0.005,1716,0.008,1717,0.003,1718,0.005,1719,0.008,1720,0.003,1721,0.005,1722,0.008,1723,0.003,1724,0.005,1725,0.008,1726,0.003,1727,0.005,1728,0.008,1729,0.003,1730,0.005,1731,0.008,1732,0.003,1733,0.005,1734,0.008,1735,0.003,1736,0.005,1737,0.008,1738,0.003,1739,0.005,1740,0.008,1741,0.003,1742,0.005,1743,0.008,1744,0.003,1745,0.005,1746,0.008,1747,0.003,1748,0.005,1749,0.008,1750,0.003,1751,0.005,1752,0.008,1753,0.003,1754,0.005,1755,0.008,1756,0.003,1757,0.005,1758,0.008,1759,0.003,1760,0.005,1761,0.008,1762,0.003,1763,0.005,1764,0.008,1765,0.003,1766,0.005,1767,0.008,1768,0.003,1769,0.005,1770,0.008,1771,0.003,1772,0.005,1773,0.008,1774,0.003,1775,0.005,1776,0.008,1777,0.003,1778,0.005,1779,0.008,1780,0.003,1781,0.005,1782,0.008,1783,0.003,1784,0.005,1785,0.008,1786,0.003,1787,0.005,1788,0.008,1789,0.003,1790,0.005,1791,0.008,1792,0.003,1793,0.005,1794,0.008,1795,0.003,1796,0.005,1797,0.008,1798,0.003,1799,0.005,1800,0.008,1801,0.003,1802,0.005,1803,0.008,1804,0.003,1805,0.005,1806,0.008,1807,0.003,1808,0.005,1809,0.008,1810,0.003,1811,0.005,1812,0.008,1813,0.003,1814,0.005,1815,0.008,1816,0.003,1817,0.005,1818,0.008,1819,0.003,1820,0.005,1821,0.008,1822,0.003,1823,0.005,1824,0.008,1825,0.003,1826,0.005,1827,0.008,1828,0.003,1829,0.005,1830,0.008,1831,0.003,1832,0.005,1833,0.008,1834,0.003,1835,0.005,1836,0.008,1837,0.003,1838,0.005,1839,0.008,1840,0.003,1841,0.005,1842,0.008,1843,0.003,1844,0.005,1845,0.008,1846,0.003,1847,0.005,1848,0.008,1849,0.003,1850,0.005,1851,0.008,1852,0.003,1853,0.005,1854,0.008,1855,0.003,1856,0.005,1857,0.008,1858,0.003,1859,0.005,1860,0.008,1861,0.003,1862,0.005,1863,0.008,1864,0.003,1865,0.005,1866,0.008,1867,0.003,1868,0.005,1869,0.008,1870,0.003,1871,0.005,1872,0.008,1873,0.003,1874,0.005,1875,0.008,1876,0.003,1877,0.005,1878,0.008,1879,0.003,1880,0.005,1881,0.008,1882,0.003,1883,0.005,1884,0.008,1885,0.003,1886,0.005,1887,0.008,1888,0.003,1889,0.005,1890,0.008,1891,0.003,1892,0.005,1893,0.008,1894,0.003,1895,0.005,1896,0.008,1897,0.003,1898,0.005,1899,0.008,1900,0.003,1901,0.005,1902,0.008,1903,0.003,1904,0.005,1905,0.008,1906,0.003,1907,0.005,1908,0.008,1909,0.003,1910,0.005,1911,0.008,1912,0.003,1913,0.005,1914,0.008,1915,0.003,1916,0.005,1917,0.008,1918,0.003,1919,0.005,1920,0.008,1921,0.003,1922,0.005,1923,0.008,1924,0.003,1925,0.005,1926,0.008,1927,0.003,1928,0.005,1929,0.008,1930,0.003,1931,0.005,1932,0.008,1933,0.003,1934,0.005,1935,0.008,1936,0.003,1937,0.005,1938,0.008,1939,0.003,1940,0.005,1941,0.008,1942,0.003,1943,0.005,1944,0.008,1945,0.003,1946,0.005,1947,0.008,1948,0.003,1949,0.005,1950,0.008,1951,0.003,1952,0.005,1953,0.008,1954,0.003,1955,0.005,1956,0.008,1957,0.003,1958,0.005,1959,0.008,1960,0.003,1961,0.005,1962,0.008,1963,0.003,1964,0.005,1965,0.008,1966,0.003,1967,0.005,1968,0.008,1969,0.003,1970,0.005,1971,0.008,1972,0.003,1973,0.005,1974,0.008,1975,0.003,1976,0.005,1977,0.008,1978,0.003,1979,0.005,1980,0.008,1981,0.003,1982,0.005,1983,0.008,1984,0.003,1985,0.005,1986,0.008,1987,0.003,1988,0.005,1989,0.008,1990,0.003,1991,0.005,1992,0.008,1993,0.003,1994,0.005,1995,0.008,1996,0.003,1997,0.005,1998,0.008,1999,0.003,2000,0.005,2001,0.008,2002,0.003,2003,0.005,2004,0.008,2005,0.003,2006,0.005,2007,0.008,2008,0.003,2009,0.005,2010,0.008,2011,0.003,2012,0.005,2013,0.008,2014,0.003,2015,0.005,2016,0.008,2017,0.003,2018,0.005,2019,0.008,2020,0.003,2021,0.005,2022,0.008,2023,0.003,2024,0.005,2025,0.008,2026,0.003,2027,0.005,2028,0.008,2029,0.003,2030,0.005,2031,0.008,2032,0.003,2033,0.005,2034,0.008,2035,0.003,2036,0.005,2037,0.008,2038,0.003,2039,0.005,2040,0.008,2041,0.003,2042,0.005,2043,0.008,2044,0.003,2045,0.005,2046,0.008,2047,0.003,2048,0.005,2049,0.008,2050,0.003,2051,0.005,2052,0.008,2053,0.003,2054,0.005,2055,0.008,2056,0.003,2057,0.005,2058,0.008,2059,0.003,2060,0.005,2061,0.008,2062,0.003,2063,0.005,2064,0.008,2065,0.003,2066,0.005,2067,0.008,2068,0.003,2069,0.005,2070,0.008,2071,0.003,2072,0.005,2073,0.008,2074,0.003,2075,0.005,2076,0.008,2077,0.003,2078,0.005,2079,0.008,2080,0.003,2081,0.005,2082,0.008,2083,0.003,2084,0.005,2085,0.008,2086,0.003,2087,0.005,2088,0.008,2089,0.003,2090,0.005,2091,0.008,2092,0.003,2093,0.005,2094,0.008,2095,0.003,2096,0.005,2097,0.008,2098,0.003,2099,0.005,2100,0.008,2101,0.003,2102,0.005,2103,0.008,2104,0.003,2105,0.005,2106,0.008,2107,0.003,2108,0.005,2109,0.008,2110,0.003,2111,0.005,2112,0.008,2113,0.003,2114,0.005,2115,0.008,2116,0.003,2117,0.005,2118,0.008,2119,0.003,2120,0.005,2121,0.008,2122,0.003,2123,0.005,2124,0.008,2125,0.003,2126,0.005,2127,0.008,2128,0.003,2129,0.005,2130,0.008,2131,0.003,2132,0.005,2133,0.008,2134,0.003,2135,0.005,2136,0.008,2137,0.003,2138,0.005,2139,0.008,2140,0.003,2141,0.005,2142,0.008,2143,0.003,2144,0.005,2145,0.008,2146,0.003,2147,0.005,2148,0.008,2149,0.003,2150,0.005,2151,0.008,2152,0.003,2153,0.005,2154,0.008,2155,0.003,2156,0.005,2157,0.008,2158,0.003,2159,0.005,2160,0.008,2161,0.003,2162,0.005,2163,0.008,2164,0.003,2165,0.005,2166,0.008,2167,0.003,2168,0.005,2169,0.008,2170,0.003,2171,0.005,2172,0.008,2173,0.003,2174,0.005,2175,0.008,2176,0.003,2177,0.005,2178,0.008,2179,0.003,2180,0.005,2181,0.008,2182,0.003,2183,0.005,2184,0.008,2185,0.003,2186,0.005,2187,0.008,2188,0.003,2189,0.005,2190,0.008,2191,0.003,2192,0.005,2193,0.008,2194,0.003,2195,0.005,2196,0.008,2197,0.003,2198,0.005,2199,0.008,2200,0.003,2201,0.005,2202,0.008,2203,0.003,2204,0.005,2205,0.008,2206,0.003,2207,0.005,2208,0.008,2209,0.003,2210,0.005,2211,0.008,2212,0.003,2213,0.005,2214,0.008,2215,0.003,2216,0.005,2217,0.008,2218,0.003,2219,0.005,2220,0.008,2221,0.003,2222,0.005,2223,0.008,2224,0.003,2225,0.005,2226,0.008,2227,0.003,2228,0.005,2229,0.008,2230,0.003,2231,0.005,2232,0.008,2233,0.003,2234,0.005,2235,0.008,2236,0.003,2237,0.005,2238,0.008,2239,0.003,2240,0.005,2241,0.008,2242,0.003,2243,0.005,2244,0.008,2245,0.003,2246,0.005,2247,0.008,2248,0.003,2249,0.005,2250,0.008,2251,0.003,2252,0.005,2253,0.008,2254,0.003,2255,0.005,2256,0.008,2257,0.003,2258,0.005,2259,0.008,2260,0.003,2261,0.005,2262,0.008,2263,0.003,2264,0.005,2265,0.008,2266,0.003,2267,0.005,2268,0.008,2269,0.003,2270,0.005,2271,0.008,2272,0.003,2273,0.005,2274,0.008,2275,0.003,2276,0.005,2277,0.008,2278,0.003,2279,0.005,2280,0.008,2281,0.003,2282,0.005,2283,0.008,2284,0.003,2285,0.005,2286,0.008,2287,0.003,2288,0.005,2289,0.008,2290,0.003,2291,0.005,2292,0.008,2293,0.003,2294,0.005,2295,0.008,2296,0.003,2297,0.005,2298,0.008,2299,0.003,2300,0.005,2301,0.008,2302,0.003,2303,0.005,2304,0.008,2305,0.003,2306,0.005,2307,0.008,2308,0.003,2309,0.005,2310,0.008,2311,0.003,2312,0.005,2313,0.008,2314,0.003,2315,0.005,2316,0.008,2317,0.003,2318,0.005,2319,0.008,2320,0.003,2321,0.005,2322,0.008,2323,0.003,2324,0.005,2325,0.008,2326,0.003,2327,0.005,2328,0.008,2329,0.003,2330,0.005,2331,0.008,2332,0.003,2333,0.005,2334,0.008,2335,0.003,2336,0.005,2337,0.008,2338,0.003,2339,0.005,2340,0.008,2341,0.003,2342,0.005,2343,0.008,2344,0.003,2345,0.005,2346,0.008,2347,0.003,2348,0.005,2349,0.008,2350,0.003,2351,0.005,2352,0.008,2353,0.003,2354,0.005,2355,0.008,2356,0.003,2357,0.005,2358,0.008,2359,0.003,2360,0.005,2361,0.008,2362,0.003,2363,0.005,2364,0.008,2365,0.003,2366,0.005,2367,0.008,2368,0.003,2369,0.005,2370,0.008,2371,0.003,2372,0.005,2373,0.008,2374,0.003,2375,0.005,2376,0.008,2377,0.003,2378,0.005,2379,0.008,2380,0.003,2381,0.005,2382,0.008,2383,0.003,2384,0.005,2385,0.008,2386,0.003,2387,0.005,2388,0.008,2389,0.003,2390,0.005,2391,0.008,2392,0.003,2393,0.005,2394,0.008,2395,0.003,2396,0.005,2397,0.008,2398,0.003,2399,0.005,2400,0.008,2401,0.003,2402,0.005,2403,0.008,2404,0.003,2405,0.005,2406,0.008,2407,0.003,2408,0.005,2409,0.008,2410,0.003,2411,0.005,2412,0.008,2413,0.003,2414,0.005,2415,0.008,2416,0.003,2417,0.005,2418,0.008,2419,0.003,2420,0.005,2421,0.008,2422,0.003,2423,0.005,2424,0.008,2425,0.003,2426,0.005,2427,0.008,2428,0.003,2429,0.005,2430,0.008,2431,0.003,2432,0.005,2433,0.008,2434,0.003,2435,0.005,2436,0.008,2437,0.003,2438,0.005,2439,0.008,2440,0.003,2441,0.005,2442,0.008,2443,0.003,2444,0.005,2445,0.008,2446,0.003,2447,0.005,2448,0.008,2449,0.003,2450,0.005,2451,0.008,2452,0.003,2453,0.005,2454,0.008,2455,0.003,2456,0.005,2457,0.008,2458,0.003,2459,0.005,2460,0.008,2461,0.003,2462,0.005,2463,0.008,2464,0.003,2465,0.005,2466,0.008,2467,0.003,2468,0.005,2469,0.008,2470,0.003,2471,0.005,2472,0.008,2473,0.003,2474,0.005,2475,0.008,2476,0.003,2477,0.005,2478,0.008,2479,0.003,2480,0.005,2481,0.008,2482,0.003,2483,0.005,2484,0.008,2485,0.003,2486,0.005,2487,0.008,2488,0.003,2489,0.005,2490,0.008,2491,0.003,2492,0.005,2493,0.008,2494,0.003,2495,0.005,2496,0.008,2497,0.003,2498,0.005,2499,0.008,2500,0.003,2501,0.005,2502,0.008,2503,0.003,2504,0.005,2505,0.008,2506,0.003,2507,0.005,2508,0.008,2509,0.003,2510,0.005,2511,0.008,2512,0.003,2513,0.005,2514,0.008,2515,0.003,2516,0.005,2517,0.008,2518,0.003,2519,0.005,2520,0.008,2521,0.003,2522,0.005,2523,0.008,2524,0.003,2525,0.005,2526,0.008,2527,0.003,2528,0.005,2529,0.008,2530,0.003,2531,0.005,2532,0.008,2533,0.003,2534,0.005,2535,0.008,2536,0.003,2537,0.005,2538,0.008,2539,0.003,2540,0.005,2541,0.008,2542,0.003,2543,0.005,2544,0.008,2545,0.003,2546,0.005,2547,0.008,2548,0.003,2549,0.005,2550,0.008,2551,0.003,2552,0.005,2553,0.008,2554,0.003,2555,0.005,2556,0.008,2557,0.003,2558,0.005,2559,0.008,2560,0.003,2561,0.005,2562,0.008,2563,0.003,2564,0.005,2565,0.008,2566,0.003,2567,0.005,2568,0.008,2569,0.003,2570,0.005,2571,0.008,2572,0.003,2573,0.005,2574,0.008,2575,0.003,2576,0.005,2577,0.008,2578,0.003,2579,0.005,2580,0.008,2581,0.003,2582,0.005,2583,0.008,2584,0.003,2585,0.005,2586,0.008,2587,0.003,2588,0.005,2589,0.008,2590,0.003,2591,0.005,2592,0.008,2593,0.003,2594,0.005,2595,0.008,2596,0.003,2597,0.005,2598,0.008,2599,0.003,2600,0.005,2601,0.008,2602,0.003,2603,0.005,2604,0.008)
.param TR={TSET/0.590334}
.param TE={TLEAD+TDIT+TR}
.param SCALE=table(run,1,0.875081,2,0.875081,3,0.875081,4,0.875081,5,0.875081,6,0.875081,7,0.875081,8,0.875081,9,0.875081,10,0.875081,11,0.875081,12,0.875081,13,0.875081,14,0.875081,15,0.875081,16,0.875081,17,0.875081,18,0.875081,19,0.875081,20,0.875081,21,0.875081,22,0.875081,23,0.875081,24,0.875081,25,0.875081,26,0.875081,27,0.875081,28,0.875081,29,0.875081,30,0.875081,31,0.875081,32,0.875081,33,0.875081,34,0.875081,35,0.875081,36,0.875081,37,0.875081,38,0.875081,39,0.875081,40,0.875081,41,0.875081,42,0.875081,43,0.875081,44,0.875081,45,0.875081,46,0.875081,47,0.875081,48,0.875081,49,0.875081,50,0.875081,51,0.875081,52,0.875081,53,0.875081,54,0.875081,55,0.875081,56,0.875081,57,0.875081,58,0.875081,59,0.875081,60,0.875081,61,0.875081,62,0.875081,63,0.875081,64,0.875081,65,0.875081,66,0.875081,67,0.875081,68,0.875081,69,0.875081,70,0.875081,71,0.875081,72,0.875081,73,0.875081,74,0.875081,75,0.875081,76,0.875081,77,0.875081,78,0.875081,79,0.875081,80,0.875081,81,0.875081,82,0.875081,83,0.875081,84,0.875081,85,0.875081,86,0.875081,87,0.875081,88,0.875081,89,0.875081,90,0.875081,91,0.875081,92,0.875081,93,0.875081,94,0.875081,95,0.875081,96,0.875081,97,0.875081,98,0.875081,99,0.875081,100,0.875081,101,0.875081,102,0.875081,103,0.875081,104,0.875081,105,0.875081,106,0.875081,107,0.875081,108,0.875081,109,0.875081,110,0.875081,111,0.875081,112,0.875081,113,0.875081,114,0.875081,115,0.875081,116,0.875081,117,0.875081,118,0.875081,119,0.875081,120,0.875081,121,0.875081,122,0.875081,123,0.875081,124,0.875081,125,0.875081,126,0.875081,127,0.875081,128,0.875081,129,0.875081,130,0.875081,131,0.875081,132,0.875081,133,0.875081,134,0.875081,135,0.875081,136,0.875081,137,0.875081,138,0.875081,139,0.875081,140,0.875081,141,0.875081,142,0.875081,143,0.875081,144,0.875081,145,0.875081,146,0.875081,147,0.875081,148,0.875081,149,0.875081,150,0.875081,151,0.875081,152,0.875081,153,0.875081,154,0.875081,155,0.875081,156,0.875081,157,0.875081,158,0.875081,159,0.875081,160,0.875081,161,0.875081,162,0.875081,163,0.875081,164,0.875081,165,0.875081,166,0.875081,167,0.875081,168,0.875081,169,0.875081,170,0.875081,171,0.875081,172,0.875081,173,0.875081,174,0.875081,175,0.875081,176,0.875081,177,0.875081,178,0.875081,179,0.875081,180,0.875081,181,0.875081,182,0.875081,183,0.875081,184,0.875081,185,0.875081,186,0.875081,187,0.875081,188,0.875081,189,0.875081,190,0.875081,191,0.875081,192,0.875081,193,0.875081,194,0.875081,195,0.875081,196,0.875081,197,0.875081,198,0.875081,199,0.875081,200,0.875081,201,0.875081,202,0.875081,203,0.875081,204,0.875081,205,0.875081,206,0.875081,207,0.875081,208,0.875081,209,0.875081,210,0.875081,211,0.875081,212,0.875081,213,0.875081,214,0.875081,215,0.875081,216,0.875081,217,0.875081,218,0.875081,219,0.875081,220,0.875081,221,0.875081,222,0.875081,223,0.875081,224,0.875081,225,0.875081,226,0.875081,227,0.875081,228,0.875081,229,0.875081,230,0.875081,231,0.875081,232,0.875081,233,0.875081,234,0.875081,235,0.875081,236,0.875081,237,0.875081,238,0.875081,239,0.875081,240,0.875081,241,0.875081,242,0.875081,243,0.875081,244,0.875081,245,0.875081,246,0.875081,247,0.875081,248,0.875081,249,0.875081,250,0.875081,251,0.875081,252,0.875081,253,0.875081,254,0.875081,255,0.875081,256,0.875081,257,0.875081,258,0.875081,259,0.875081,260,0.875081,261,0.875081,262,0.875081,263,0.875081,264,0.875081,265,0.875081,266,0.875081,267,0.875081,268,0.875081,269,0.875081,270,0.875081,271,0.875081,272,0.875081,273,0.875081,274,0.875081,275,0.875081,276,0.875081,277,0.875081,278,0.875081,279,0.875081,280,0.875081,281,0.875081,282,0.875081,283,0.875081,284,0.875081,285,0.875081,286,0.875081,287,0.875081,288,0.875081,289,0.875081,290,0.875081,291,0.875081,292,0.875081,293,0.875081,294,0.875081,295,0.875081,296,0.875081,297,0.875081,298,0.875081,299,0.875081,300,0.875081,301,0.875081,302,0.875081,303,0.875081,304,0.875081,305,0.875081,306,0.875081,307,0.875081,308,0.875081,309,0.875081,310,0.875081,311,0.875081,312,0.875081,313,0.875081,314,0.875081,315,0.875081,316,0.875081,317,0.875081,318,0.875081,319,0.875081,320,0.875081,321,0.875081,322,0.875081,323,0.875081,324,0.875081,325,0.875081,326,0.875081,327,0.875081,328,0.875081,329,0.875081,330,0.875081,331,0.875081,332,0.875081,333,0.875081,334,0.875081,335,0.875081,336,0.875081,337,0.875081,338,0.875081,339,0.875081,340,0.875081,341,0.875081,342,0.875081,343,0.875081,344,0.875081,345,0.875081,346,0.875081,347,0.875081,348,0.875081,349,0.875081,350,0.875081,351,0.875081,352,0.875081,353,0.875081,354,0.875081,355,0.875081,356,0.875081,357,0.875081,358,0.875081,359,0.875081,360,0.875081,361,0.875081,362,0.875081,363,0.875081,364,0.875081,365,0.875081,366,0.875081,367,0.875081,368,0.875081,369,0.875081,370,0.875081,371,0.875081,372,0.875081,373,0.875081,374,0.875081,375,0.875081,376,0.875081,377,0.875081,378,0.875081,379,0.875081,380,0.875081,381,0.875081,382,0.875081,383,0.875081,384,0.875081,385,0.875081,386,0.875081,387,0.875081,388,0.875081,389,0.875081,390,0.875081,391,0.875081,392,0.875081,393,0.875081,394,0.875081,395,0.875081,396,0.875081,397,0.875081,398,0.875081,399,0.875081,400,0.875081,401,0.875081,402,0.875081,403,0.875081,404,0.875081,405,0.875081,406,0.875081,407,0.875081,408,0.875081,409,0.875081,410,0.875081,411,0.875081,412,0.875081,413,0.875081,414,0.875081,415,0.875081,416,0.875081,417,0.875081,418,0.875081,419,0.875081,420,0.875081,421,0.875081,422,0.875081,423,0.875081,424,0.875081,425,0.875081,426,0.875081,427,0.875081,428,0.875081,429,0.875081,430,0.875081,431,0.875081,432,0.875081,433,0.875081,434,0.875081,435,0.875081,436,0.875081,437,0.875081,438,0.875081,439,0.875081,440,0.875081,441,0.875081,442,0.875081,443,0.875081,444,0.875081,445,0.875081,446,0.875081,447,0.875081,448,0.875081,449,0.875081,450,0.875081,451,0.875081,452,0.875081,453,0.875081,454,0.875081,455,0.875081,456,0.875081,457,0.875081,458,0.875081,459,0.875081,460,0.875081,461,0.875081,462,0.875081,463,0.875081,464,0.875081,465,0.875081,466,0.875081,467,0.875081,468,0.875081,469,0.875081,470,0.875081,471,0.875081,472,0.875081,473,0.875081,474,0.875081,475,0.875081,476,0.875081,477,0.875081,478,0.875081,479,0.875081,480,0.875081,481,0.875081,482,0.875081,483,0.875081,484,0.875081,485,0.875081,486,0.875081,487,0.875081,488,0.875081,489,0.875081,490,0.875081,491,0.875081,492,0.875081,493,0.875081,494,0.875081,495,0.875081,496,0.875081,497,0.875081,498,0.875081,499,0.875081,500,0.875081,501,0.875081,502,0.875081,503,0.875081,504,0.875081,505,0.875081,506,0.875081,507,0.875081,508,0.875081,509,0.875081,510,0.875081,511,0.875081,512,0.875081,513,0.875081,514,0.875081,515,0.875081,516,0.875081,517,0.875081,518,0.875081,519,0.875081,520,0.875081,521,0.875081,522,0.875081,523,0.875081,524,0.875081,525,0.875081,526,0.875081,527,0.875081,528,0.875081,529,0.875081,530,0.875081,531,0.875081,532,0.875081,533,0.875081,534,0.875081,535,0.875081,536,0.875081,537,0.875081,538,0.875081,539,0.875081,540,0.875081,541,0.875081,542,0.875081,543,0.875081,544,0.875081,545,0.875081,546,0.875081,547,0.875081,548,0.875081,549,0.875081,550,0.875081,551,0.875081,552,0.875081,553,0.875081,554,0.875081,555,0.875081,556,0.875081,557,0.875081,558,0.875081,559,0.875081,560,0.875081,561,0.875081,562,0.875081,563,0.875081,564,0.875081,565,0.875081,566,0.875081,567,0.875081,568,0.875081,569,0.875081,570,0.875081,571,0.875081,572,0.875081,573,0.875081,574,0.875081,575,0.875081,576,0.875081,577,0.875081,578,0.875081,579,0.875081,580,0.875081,581,0.875081,582,0.875081,583,0.875081,584,0.875081,585,0.875081,586,0.875081,587,0.875081,588,0.875081,589,0.875081,590,0.875081,591,0.875081,592,0.875081,593,0.875081,594,0.875081,595,0.875081,596,0.875081,597,0.875081,598,0.875081,599,0.875081,600,0.875081,601,0.875081,602,0.875081,603,0.875081,604,0.875081,605,0.875081,606,0.875081,607,0.875081,608,0.875081,609,0.875081,610,0.875081,611,0.875081,612,0.875081,613,0.875081,614,0.875081,615,0.875081,616,0.875081,617,0.875081,618,0.875081,619,0.875081,620,0.875081,621,0.875081,622,0.875081,623,0.875081,624,0.875081,625,0.875081,626,0.875081,627,0.875081,628,0.875081,629,0.875081,630,0.875081,631,0.875081,632,0.875081,633,0.875081,634,0.875081,635,0.875081,636,0.875081,637,0.875081,638,0.875081,639,0.875081,640,0.875081,641,0.875081,642,0.875081,643,0.875081,644,0.875081,645,0.875081,646,0.875081,647,0.875081,648,0.875081,649,0.875081,650,0.875081,651,0.875081,652,0.875081,653,0.875081,654,0.875081,655,0.875081,656,0.875081,657,0.875081,658,0.875081,659,0.875081,660,0.875081,661,0.875081,662,0.875081,663,0.875081,664,0.875081,665,0.875081,666,0.875081,667,0.875081,668,0.875081,669,0.875081,670,0.875081,671,0.875081,672,0.875081,673,0.875081,674,0.875081,675,0.875081,676,0.875081,677,0.875081,678,0.875081,679,0.875081,680,0.875081,681,0.875081,682,0.875081,683,0.875081,684,0.875081,685,0.875081,686,0.875081,687,0.875081,688,0.875081,689,0.875081,690,0.875081,691,0.875081,692,0.875081,693,0.875081,694,0.875081,695,0.875081,696,0.875081,697,0.875081,698,0.875081,699,0.875081,700,0.875081,701,0.875081,702,0.875081,703,0.875081,704,0.875081,705,0.875081,706,0.875081,707,0.875081,708,0.875081,709,0.875081,710,0.875081,711,0.875081,712,0.875081,713,0.875081,714,0.875081,715,0.875081,716,0.875081,717,0.875081,718,0.875081,719,0.875081,720,0.875081,721,0.875081,722,0.875081,723,0.875081,724,0.875081,725,0.875081,726,0.875081,727,0.875081,728,0.875081,729,0.875081,730,0.875081,731,0.875081,732,0.875081,733,0.875081,734,0.875081,735,0.875081,736,0.875081,737,0.875081,738,0.875081,739,0.875081,740,0.875081,741,0.875081,742,0.875081,743,0.875081,744,0.875081,745,0.875081,746,0.875081,747,0.875081,748,0.875081,749,0.875081,750,0.875081,751,0.875081,752,0.875081,753,0.875081,754,0.875081,755,0.875081,756,0.875081,757,0.875081,758,0.875081,759,0.875081,760,0.875081,761,0.875081,762,0.875081,763,0.875081,764,0.875081,765,0.875081,766,0.875081,767,0.875081,768,0.875081,769,0.875081,770,0.875081,771,0.875081,772,0.875081,773,0.875081,774,0.875081,775,0.875081,776,0.875081,777,0.875081,778,0.875081,779,0.875081,780,0.875081,781,0.875081,782,0.875081,783,0.875081,784,0.875081,785,0.875081,786,0.875081,787,0.875081,788,0.875081,789,0.875081,790,0.875081,791,0.875081,792,0.875081,793,0.875081,794,0.875081,795,0.875081,796,0.875081,797,0.875081,798,0.875081,799,0.875081,800,0.875081,801,0.875081,802,0.875081,803,0.875081,804,0.875081,805,0.875081,806,0.875081,807,0.875081,808,0.875081,809,0.875081,810,0.875081,811,0.875081,812,0.875081,813,0.875081,814,0.875081,815,0.875081,816,0.875081,817,0.875081,818,0.875081,819,0.875081,820,0.875081,821,0.875081,822,0.875081,823,0.875081,824,0.875081,825,0.875081,826,0.875081,827,0.875081,828,0.875081,829,0.875081,830,0.875081,831,0.875081,832,0.875081,833,0.875081,834,0.875081,835,0.875081,836,0.875081,837,0.875081,838,0.875081,839,0.875081,840,0.875081,841,0.875081,842,0.875081,843,0.875081,844,0.875081,845,0.875081,846,0.875081,847,0.875081,848,0.875081,849,0.875081,850,0.875081,851,0.875081,852,0.875081,853,0.875081,854,0.875081,855,0.875081,856,0.875081,857,0.875081,858,0.875081,859,0.875081,860,0.875081,861,0.875081,862,0.875081,863,0.875081,864,0.875081,865,0.875081,866,0.875081,867,0.875081,868,0.875081,869,0.875081,870,0.875081,871,0.875081,872,0.875081,873,0.875081,874,0.875081,875,0.875081,876,0.875081,877,0.875081,878,0.875081,879,0.875081,880,0.875081,881,0.875081,882,0.875081,883,0.875081,884,0.875081,885,0.875081,886,0.875081,887,0.875081,888,0.875081,889,0.875081,890,0.875081,891,0.875081,892,0.875081,893,0.875081,894,0.875081,895,0.875081,896,0.875081,897,0.875081,898,0.875081,899,0.875081,900,0.875081,901,0.875081,902,0.875081,903,0.875081,904,0.875081,905,0.875081,906,0.875081,907,0.875081,908,0.875081,909,0.875081,910,0.875081,911,0.875081,912,0.875081,913,0.875081,914,0.875081,915,0.875081,916,0.875081,917,0.875081,918,0.875081,919,0.875081,920,0.875081,921,0.875081,922,0.875081,923,0.875081,924,0.875081,925,0.875081,926,0.875081,927,0.875081,928,0.875081,929,0.875081,930,0.875081,931,0.875081,932,0.875081,933,0.875081,934,0.875081,935,0.875081,936,0.875081,937,0.875081,938,0.875081,939,0.875081,940,0.875081,941,0.875081,942,0.875081,943,0.875081,944,0.875081,945,0.875081,946,0.875081,947,0.875081,948,0.875081,949,0.875081,950,0.875081,951,0.875081,952,0.875081,953,0.875081,954,0.875081,955,0.875081,956,0.875081,957,0.875081,958,0.875081,959,0.875081,960,0.875081,961,0.875081,962,0.875081,963,0.875081,964,0.875081,965,0.875081,966,0.875081,967,0.875081,968,0.875081,969,0.875081,970,0.875081,971,0.875081,972,0.875081,973,0.875081,974,0.875081,975,0.875081,976,0.875081,977,0.875081,978,0.875081,979,0.875081,980,0.875081,981,0.875081,982,0.875081,983,0.875081,984,0.875081,985,0.875081,986,0.875081,987,0.875081,988,0.875081,989,0.875081,990,0.875081,991,0.875081,992,0.875081,993,0.875081,994,0.875081,995,0.875081,996,0.875081,997,0.875081,998,0.875081,999,0.875081,1000,0.875081,1001,0.875081,1002,0.875081,1003,0.875081,1004,0.875081,1005,0.875081,1006,0.875081,1007,0.875081,1008,0.875081,1009,0.875081,1010,0.875081,1011,0.875081,1012,0.875081,1013,0.875081,1014,0.875081,1015,0.875081,1016,0.875081,1017,0.875081,1018,0.875081,1019,0.875081,1020,0.875081,1021,0.875081,1022,0.875081,1023,0.875081,1024,0.875081,1025,0.875081,1026,0.875081,1027,0.875081,1028,0.875081,1029,0.875081,1030,0.875081,1031,0.875081,1032,0.875081,1033,0.875081,1034,0.875081,1035,0.875081,1036,0.875081,1037,0.875081,1038,0.875081,1039,0.875081,1040,0.875081,1041,0.875081,1042,0.875081,1043,0.875081,1044,0.875081,1045,0.875081,1046,0.875081,1047,0.875081,1048,0.875081,1049,0.875081,1050,0.875081,1051,0.875081,1052,0.875081,1053,0.875081,1054,0.875081,1055,0.875081,1056,0.875081,1057,0.875081,1058,0.875081,1059,0.875081,1060,0.875081,1061,0.875081,1062,0.875081,1063,0.875081,1064,0.875081,1065,0.875081,1066,0.875081,1067,0.875081,1068,0.875081,1069,0.875081,1070,0.875081,1071,0.875081,1072,0.875081,1073,0.875081,1074,0.875081,1075,0.875081,1076,0.875081,1077,0.875081,1078,0.875081,1079,0.875081,1080,0.875081,1081,0.875081,1082,0.875081,1083,0.875081,1084,0.875081,1085,0.875081,1086,0.875081,1087,0.875081,1088,0.875081,1089,0.875081,1090,0.875081,1091,0.875081,1092,0.875081,1093,0.875081,1094,0.875081,1095,0.875081,1096,0.875081,1097,0.875081,1098,0.875081,1099,0.875081,1100,0.875081,1101,0.875081,1102,0.875081,1103,0.875081,1104,0.875081,1105,0.875081,1106,0.875081,1107,0.875081,1108,0.875081,1109,0.875081,1110,0.875081,1111,0.875081,1112,0.875081,1113,0.875081,1114,0.875081,1115,0.875081,1116,0.875081,1117,0.606107,1118,0.606107,1119,0.606107,1120,0.606107,1121,0.606107,1122,0.606107,1123,0.606107,1124,0.606107,1125,0.606107,1126,0.606107,1127,0.606107,1128,0.606107,1129,0.606107,1130,0.606107,1131,0.606107,1132,0.606107,1133,0.606107,1134,0.606107,1135,0.606107,1136,0.606107,1137,0.606107,1138,0.606107,1139,0.606107,1140,0.606107,1141,0.606107,1142,0.606107,1143,0.606107,1144,0.606107,1145,0.606107,1146,0.606107,1147,0.606107,1148,0.606107,1149,0.606107,1150,0.606107,1151,0.606107,1152,0.606107,1153,0.606107,1154,0.606107,1155,0.606107,1156,0.606107,1157,0.606107,1158,0.606107,1159,0.606107,1160,0.606107,1161,0.606107,1162,0.606107,1163,0.606107,1164,0.606107,1165,0.606107,1166,0.606107,1167,0.606107,1168,0.606107,1169,0.606107,1170,0.606107,1171,0.606107,1172,0.606107,1173,0.606107,1174,0.606107,1175,0.606107,1176,0.606107,1177,0.606107,1178,0.606107,1179,0.606107,1180,0.606107,1181,0.606107,1182,0.606107,1183,0.606107,1184,0.606107,1185,0.606107,1186,0.606107,1187,0.606107,1188,0.606107,1189,0.606107,1190,0.606107,1191,0.606107,1192,0.606107,1193,0.606107,1194,0.606107,1195,0.606107,1196,0.606107,1197,0.606107,1198,0.606107,1199,0.606107,1200,0.606107,1201,0.606107,1202,0.606107,1203,0.606107,1204,0.606107,1205,0.606107,1206,0.606107,1207,0.606107,1208,0.606107,1209,0.606107,1210,0.606107,1211,0.606107,1212,0.606107,1213,0.606107,1214,0.606107,1215,0.606107,1216,0.606107,1217,0.606107,1218,0.606107,1219,0.606107,1220,0.606107,1221,0.606107,1222,0.606107,1223,0.606107,1224,0.606107,1225,0.606107,1226,0.606107,1227,0.606107,1228,0.606107,1229,0.606107,1230,0.606107,1231,0.606107,1232,0.606107,1233,0.606107,1234,0.606107,1235,0.606107,1236,0.606107,1237,0.606107,1238,0.606107,1239,0.606107,1240,0.606107,1241,0.606107,1242,0.606107,1243,0.606107,1244,0.606107,1245,0.606107,1246,0.606107,1247,0.606107,1248,0.606107,1249,0.606107,1250,0.606107,1251,0.606107,1252,0.606107,1253,0.606107,1254,0.606107,1255,0.606107,1256,0.606107,1257,0.606107,1258,0.606107,1259,0.606107,1260,0.606107,1261,0.606107,1262,0.606107,1263,0.606107,1264,0.606107,1265,0.606107,1266,0.606107,1267,0.606107,1268,0.606107,1269,0.606107,1270,0.606107,1271,0.606107,1272,0.606107,1273,0.606107,1274,0.606107,1275,0.606107,1276,0.606107,1277,0.606107,1278,0.606107,1279,0.606107,1280,0.606107,1281,0.606107,1282,0.606107,1283,0.606107,1284,0.606107,1285,0.606107,1286,0.606107,1287,0.606107,1288,0.606107,1289,0.606107,1290,0.606107,1291,0.606107,1292,0.606107,1293,0.606107,1294,0.606107,1295,0.606107,1296,0.606107,1297,0.606107,1298,0.606107,1299,0.606107,1300,0.606107,1301,0.606107,1302,0.606107,1303,0.606107,1304,0.606107,1305,0.606107,1306,0.606107,1307,0.606107,1308,0.606107,1309,0.606107,1310,0.606107,1311,0.606107,1312,0.606107,1313,0.606107,1314,0.606107,1315,0.606107,1316,0.606107,1317,0.606107,1318,0.606107,1319,0.606107,1320,0.606107,1321,0.606107,1322,0.606107,1323,0.606107,1324,0.606107,1325,0.606107,1326,0.606107,1327,0.606107,1328,0.606107,1329,0.606107,1330,0.606107,1331,0.606107,1332,0.606107,1333,0.606107,1334,0.606107,1335,0.606107,1336,0.606107,1337,0.606107,1338,0.606107,1339,0.606107,1340,0.606107,1341,0.606107,1342,0.606107,1343,0.606107,1344,0.606107,1345,0.606107,1346,0.606107,1347,0.606107,1348,0.606107,1349,0.606107,1350,0.606107,1351,0.606107,1352,0.606107,1353,0.606107,1354,0.606107,1355,0.606107,1356,0.606107,1357,0.606107,1358,0.606107,1359,0.606107,1360,0.606107,1361,0.606107,1362,0.606107,1363,0.606107,1364,0.606107,1365,0.606107,1366,0.606107,1367,0.606107,1368,0.606107,1369,0.606107,1370,0.606107,1371,0.606107,1372,0.606107,1373,0.606107,1374,0.606107,1375,0.606107,1376,0.606107,1377,0.606107,1378,0.606107,1379,0.606107,1380,0.606107,1381,0.606107,1382,0.606107,1383,0.606107,1384,0.606107,1385,0.606107,1386,0.606107,1387,0.606107,1388,0.606107,1389,0.606107,1390,0.606107,1391,0.606107,1392,0.606107,1393,0.606107,1394,0.606107,1395,0.606107,1396,0.606107,1397,0.606107,1398,0.606107,1399,0.606107,1400,0.606107,1401,0.606107,1402,0.606107,1403,0.606107,1404,0.606107,1405,0.606107,1406,0.606107,1407,0.606107,1408,0.606107,1409,0.606107,1410,0.606107,1411,0.606107,1412,0.606107,1413,0.606107,1414,0.606107,1415,0.606107,1416,0.606107,1417,0.606107,1418,0.606107,1419,0.606107,1420,0.606107,1421,0.606107,1422,0.606107,1423,0.606107,1424,0.606107,1425,0.606107,1426,0.606107,1427,0.606107,1428,0.606107,1429,0.606107,1430,0.606107,1431,0.606107,1432,0.606107,1433,0.606107,1434,0.606107,1435,0.606107,1436,0.606107,1437,0.606107,1438,0.606107,1439,0.606107,1440,0.606107,1441,0.606107,1442,0.606107,1443,0.606107,1444,0.606107,1445,0.606107,1446,0.606107,1447,0.606107,1448,0.606107,1449,0.606107,1450,0.606107,1451,0.606107,1452,0.606107,1453,0.606107,1454,0.606107,1455,0.606107,1456,0.606107,1457,0.606107,1458,0.606107,1459,0.606107,1460,0.606107,1461,0.606107,1462,0.606107,1463,0.606107,1464,0.606107,1465,0.606107,1466,0.606107,1467,0.606107,1468,0.606107,1469,0.606107,1470,0.606107,1471,0.606107,1472,0.606107,1473,0.606107,1474,0.606107,1475,0.606107,1476,0.606107,1477,0.606107,1478,0.606107,1479,0.606107,1480,0.606107,1481,0.606107,1482,0.606107,1483,0.606107,1484,0.606107,1485,0.606107,1486,0.606107,1487,0.606107,1488,0.606107,1489,1.17985,1490,1.17985,1491,1.17985,1492,1.17985,1493,1.17985,1494,1.17985,1495,1.17985,1496,1.17985,1497,1.17985,1498,1.17985,1499,1.17985,1500,1.17985,1501,1.17985,1502,1.17985,1503,1.17985,1504,1.17985,1505,1.17985,1506,1.17985,1507,1.17985,1508,1.17985,1509,1.17985,1510,1.17985,1511,1.17985,1512,1.17985,1513,1.17985,1514,1.17985,1515,1.17985,1516,1.17985,1517,1.17985,1518,1.17985,1519,1.17985,1520,1.17985,1521,1.17985,1522,1.17985,1523,1.17985,1524,1.17985,1525,1.17985,1526,1.17985,1527,1.17985,1528,1.17985,1529,1.17985,1530,1.17985,1531,1.17985,1532,1.17985,1533,1.17985,1534,1.17985,1535,1.17985,1536,1.17985,1537,1.17985,1538,1.17985,1539,1.17985,1540,1.17985,1541,1.17985,1542,1.17985,1543,1.17985,1544,1.17985,1545,1.17985,1546,1.17985,1547,1.17985,1548,1.17985,1549,1.17985,1550,1.17985,1551,1.17985,1552,1.17985,1553,1.17985,1554,1.17985,1555,1.17985,1556,1.17985,1557,1.17985,1558,1.17985,1559,1.17985,1560,1.17985,1561,1.17985,1562,1.17985,1563,1.17985,1564,1.17985,1565,1.17985,1566,1.17985,1567,1.17985,1568,1.17985,1569,1.17985,1570,1.17985,1571,1.17985,1572,1.17985,1573,1.17985,1574,1.17985,1575,1.17985,1576,1.17985,1577,1.17985,1578,1.17985,1579,1.17985,1580,1.17985,1581,1.17985,1582,1.17985,1583,1.17985,1584,1.17985,1585,1.17985,1586,1.17985,1587,1.17985,1588,1.17985,1589,1.17985,1590,1.17985,1591,1.17985,1592,1.17985,1593,1.17985,1594,1.17985,1595,1.17985,1596,1.17985,1597,1.17985,1598,1.17985,1599,1.17985,1600,1.17985,1601,1.17985,1602,1.17985,1603,1.17985,1604,1.17985,1605,1.17985,1606,1.17985,1607,1.17985,1608,1.17985,1609,1.17985,1610,1.17985,1611,1.17985,1612,1.17985,1613,1.17985,1614,1.17985,1615,1.17985,1616,1.17985,1617,1.17985,1618,1.17985,1619,1.17985,1620,1.17985,1621,1.17985,1622,1.17985,1623,1.17985,1624,1.17985,1625,1.17985,1626,1.17985,1627,1.17985,1628,1.17985,1629,1.17985,1630,1.17985,1631,1.17985,1632,1.17985,1633,1.17985,1634,1.17985,1635,1.17985,1636,1.17985,1637,1.17985,1638,1.17985,1639,1.17985,1640,1.17985,1641,1.17985,1642,1.17985,1643,1.17985,1644,1.17985,1645,1.17985,1646,1.17985,1647,1.17985,1648,1.17985,1649,1.17985,1650,1.17985,1651,1.17985,1652,1.17985,1653,1.17985,1654,1.17985,1655,1.17985,1656,1.17985,1657,1.17985,1658,1.17985,1659,1.17985,1660,1.17985,1661,1.17985,1662,1.17985,1663,1.17985,1664,1.17985,1665,1.17985,1666,1.17985,1667,1.17985,1668,1.17985,1669,1.17985,1670,1.17985,1671,1.17985,1672,1.17985,1673,1.17985,1674,1.17985,1675,1.17985,1676,1.17985,1677,1.17985,1678,1.17985,1679,1.17985,1680,1.17985,1681,1.17985,1682,1.17985,1683,1.17985,1684,1.17985,1685,1.17985,1686,1.17985,1687,1.17985,1688,1.17985,1689,1.17985,1690,1.17985,1691,1.17985,1692,1.17985,1693,1.17985,1694,1.17985,1695,1.17985,1696,1.17985,1697,1.17985,1698,1.17985,1699,1.17985,1700,1.17985,1701,1.17985,1702,1.17985,1703,1.17985,1704,1.17985,1705,1.17985,1706,1.17985,1707,1.17985,1708,1.17985,1709,1.17985,1710,1.17985,1711,1.17985,1712,1.17985,1713,1.17985,1714,1.17985,1715,1.17985,1716,1.17985,1717,1.17985,1718,1.17985,1719,1.17985,1720,1.17985,1721,1.17985,1722,1.17985,1723,1.17985,1724,1.17985,1725,1.17985,1726,1.17985,1727,1.17985,1728,1.17985,1729,1.17985,1730,1.17985,1731,1.17985,1732,1.17985,1733,1.17985,1734,1.17985,1735,1.17985,1736,1.17985,1737,1.17985,1738,1.17985,1739,1.17985,1740,1.17985,1741,1.17985,1742,1.17985,1743,1.17985,1744,1.17985,1745,1.17985,1746,1.17985,1747,1.17985,1748,1.17985,1749,1.17985,1750,1.17985,1751,1.17985,1752,1.17985,1753,1.17985,1754,1.17985,1755,1.17985,1756,1.17985,1757,1.17985,1758,1.17985,1759,1.17985,1760,1.17985,1761,1.17985,1762,1.17985,1763,1.17985,1764,1.17985,1765,1.17985,1766,1.17985,1767,1.17985,1768,1.17985,1769,1.17985,1770,1.17985,1771,1.17985,1772,1.17985,1773,1.17985,1774,1.17985,1775,1.17985,1776,1.17985,1777,1.17985,1778,1.17985,1779,1.17985,1780,1.17985,1781,1.17985,1782,1.17985,1783,1.17985,1784,1.17985,1785,1.17985,1786,1.17985,1787,1.17985,1788,1.17985,1789,1.17985,1790,1.17985,1791,1.17985,1792,1.17985,1793,1.17985,1794,1.17985,1795,1.17985,1796,1.17985,1797,1.17985,1798,1.17985,1799,1.17985,1800,1.17985,1801,1.17985,1802,1.17985,1803,1.17985,1804,1.17985,1805,1.17985,1806,1.17985,1807,1.17985,1808,1.17985,1809,1.17985,1810,1.17985,1811,1.17985,1812,1.17985,1813,1.17985,1814,1.17985,1815,1.17985,1816,1.17985,1817,1.17985,1818,1.17985,1819,1.17985,1820,1.17985,1821,1.17985,1822,1.17985,1823,1.17985,1824,1.17985,1825,1.17985,1826,1.17985,1827,1.17985,1828,1.17985,1829,1.17985,1830,1.17985,1831,1.17985,1832,1.17985,1833,1.17985,1834,1.17985,1835,1.17985,1836,1.17985,1837,1.17985,1838,1.17985,1839,1.17985,1840,1.17985,1841,1.17985,1842,1.17985,1843,1.17985,1844,1.17985,1845,1.17985,1846,1.17985,1847,1.17985,1848,1.17985,1849,1.17985,1850,1.17985,1851,1.17985,1852,1.17985,1853,1.17985,1854,1.17985,1855,1.17985,1856,1.17985,1857,1.17985,1858,1.17985,1859,1.17985,1860,1.17985,1861,0.875081,1862,0.875081,1863,0.875081,1864,0.875081,1865,0.875081,1866,0.875081,1867,0.875081,1868,0.875081,1869,0.875081,1870,0.875081,1871,0.875081,1872,0.875081,1873,0.875081,1874,0.875081,1875,0.875081,1876,0.875081,1877,0.875081,1878,0.875081,1879,0.875081,1880,0.875081,1881,0.875081,1882,0.875081,1883,0.875081,1884,0.875081,1885,0.875081,1886,0.875081,1887,0.875081,1888,0.875081,1889,0.875081,1890,0.875081,1891,0.875081,1892,0.875081,1893,0.875081,1894,0.875081,1895,0.875081,1896,0.875081,1897,0.875081,1898,0.875081,1899,0.875081,1900,0.875081,1901,0.875081,1902,0.875081,1903,0.875081,1904,0.875081,1905,0.875081,1906,0.875081,1907,0.875081,1908,0.875081,1909,0.875081,1910,0.875081,1911,0.875081,1912,0.875081,1913,0.875081,1914,0.875081,1915,0.875081,1916,0.875081,1917,0.875081,1918,0.875081,1919,0.875081,1920,0.875081,1921,0.875081,1922,0.875081,1923,0.875081,1924,0.875081,1925,0.875081,1926,0.875081,1927,0.875081,1928,0.875081,1929,0.875081,1930,0.875081,1931,0.875081,1932,0.875081,1933,0.875081,1934,0.875081,1935,0.875081,1936,0.875081,1937,0.875081,1938,0.875081,1939,0.875081,1940,0.875081,1941,0.875081,1942,0.875081,1943,0.875081,1944,0.875081,1945,0.875081,1946,0.875081,1947,0.875081,1948,0.875081,1949,0.875081,1950,0.875081,1951,0.875081,1952,0.875081,1953,0.875081,1954,0.875081,1955,0.875081,1956,0.875081,1957,0.875081,1958,0.875081,1959,0.875081,1960,0.875081,1961,0.875081,1962,0.875081,1963,0.875081,1964,0.875081,1965,0.875081,1966,0.875081,1967,0.875081,1968,0.875081,1969,0.875081,1970,0.875081,1971,0.875081,1972,0.875081,1973,0.875081,1974,0.875081,1975,0.875081,1976,0.875081,1977,0.875081,1978,0.875081,1979,0.875081,1980,0.875081,1981,0.875081,1982,0.875081,1983,0.875081,1984,0.875081,1985,0.875081,1986,0.875081,1987,0.875081,1988,0.875081,1989,0.875081,1990,0.875081,1991,0.875081,1992,0.875081,1993,0.875081,1994,0.875081,1995,0.875081,1996,0.875081,1997,0.875081,1998,0.875081,1999,0.875081,2000,0.875081,2001,0.875081,2002,0.875081,2003,0.875081,2004,0.875081,2005,0.875081,2006,0.875081,2007,0.875081,2008,0.875081,2009,0.875081,2010,0.875081,2011,0.875081,2012,0.875081,2013,0.875081,2014,0.875081,2015,0.875081,2016,0.875081,2017,0.875081,2018,0.875081,2019,0.875081,2020,0.875081,2021,0.875081,2022,0.875081,2023,0.875081,2024,0.875081,2025,0.875081,2026,0.875081,2027,0.875081,2028,0.875081,2029,0.875081,2030,0.875081,2031,0.875081,2032,0.875081,2033,0.875081,2034,0.875081,2035,0.875081,2036,0.875081,2037,0.875081,2038,0.875081,2039,0.875081,2040,0.875081,2041,0.875081,2042,0.875081,2043,0.875081,2044,0.875081,2045,0.875081,2046,0.875081,2047,0.875081,2048,0.875081,2049,0.875081,2050,0.875081,2051,0.875081,2052,0.875081,2053,0.875081,2054,0.875081,2055,0.875081,2056,0.875081,2057,0.875081,2058,0.875081,2059,0.875081,2060,0.875081,2061,0.875081,2062,0.875081,2063,0.875081,2064,0.875081,2065,0.875081,2066,0.875081,2067,0.875081,2068,0.875081,2069,0.875081,2070,0.875081,2071,0.875081,2072,0.875081,2073,0.875081,2074,0.875081,2075,0.875081,2076,0.875081,2077,0.875081,2078,0.875081,2079,0.875081,2080,0.875081,2081,0.875081,2082,0.875081,2083,0.875081,2084,0.875081,2085,0.875081,2086,0.875081,2087,0.875081,2088,0.875081,2089,0.875081,2090,0.875081,2091,0.875081,2092,0.875081,2093,0.875081,2094,0.875081,2095,0.875081,2096,0.875081,2097,0.875081,2098,0.875081,2099,0.875081,2100,0.875081,2101,0.875081,2102,0.875081,2103,0.875081,2104,0.875081,2105,0.875081,2106,0.875081,2107,0.875081,2108,0.875081,2109,0.875081,2110,0.875081,2111,0.875081,2112,0.875081,2113,0.875081,2114,0.875081,2115,0.875081,2116,0.875081,2117,0.875081,2118,0.875081,2119,0.875081,2120,0.875081,2121,0.875081,2122,0.875081,2123,0.875081,2124,0.875081,2125,0.875081,2126,0.875081,2127,0.875081,2128,0.875081,2129,0.875081,2130,0.875081,2131,0.875081,2132,0.875081,2133,0.875081,2134,0.875081,2135,0.875081,2136,0.875081,2137,0.875081,2138,0.875081,2139,0.875081,2140,0.875081,2141,0.875081,2142,0.875081,2143,0.875081,2144,0.875081,2145,0.875081,2146,0.875081,2147,0.875081,2148,0.875081,2149,0.875081,2150,0.875081,2151,0.875081,2152,0.875081,2153,0.875081,2154,0.875081,2155,0.875081,2156,0.875081,2157,0.875081,2158,0.875081,2159,0.875081,2160,0.875081,2161,0.875081,2162,0.875081,2163,0.875081,2164,0.875081,2165,0.875081,2166,0.875081,2167,0.875081,2168,0.875081,2169,0.875081,2170,0.875081,2171,0.875081,2172,0.875081,2173,0.875081,2174,0.875081,2175,0.875081,2176,0.875081,2177,0.875081,2178,0.875081,2179,0.875081,2180,0.875081,2181,0.875081,2182,0.875081,2183,0.875081,2184,0.875081,2185,0.875081,2186,0.875081,2187,0.875081,2188,0.875081,2189,0.875081,2190,0.875081,2191,0.875081,2192,0.875081,2193,0.875081,2194,0.875081,2195,0.875081,2196,0.875081,2197,0.875081,2198,0.875081,2199,0.875081,2200,0.875081,2201,0.875081,2202,0.875081,2203,0.875081,2204,0.875081,2205,0.875081,2206,0.875081,2207,0.875081,2208,0.875081,2209,0.875081,2210,0.875081,2211,0.875081,2212,0.875081,2213,0.875081,2214,0.875081,2215,0.875081,2216,0.875081,2217,0.875081,2218,0.875081,2219,0.875081,2220,0.875081,2221,0.875081,2222,0.875081,2223,0.875081,2224,0.875081,2225,0.875081,2226,0.875081,2227,0.875081,2228,0.875081,2229,0.875081,2230,0.875081,2231,0.875081,2232,0.875081,2233,0.875081,2234,0.875081,2235,0.875081,2236,0.875081,2237,0.875081,2238,0.875081,2239,0.875081,2240,0.875081,2241,0.875081,2242,0.875081,2243,0.875081,2244,0.875081,2245,0.875081,2246,0.875081,2247,0.875081,2248,0.875081,2249,0.875081,2250,0.875081,2251,0.875081,2252,0.875081,2253,0.875081,2254,0.875081,2255,0.875081,2256,0.875081,2257,0.875081,2258,0.875081,2259,0.875081,2260,0.875081,2261,0.875081,2262,0.875081,2263,0.875081,2264,0.875081,2265,0.875081,2266,0.875081,2267,0.875081,2268,0.875081,2269,0.875081,2270,0.875081,2271,0.875081,2272,0.875081,2273,0.875081,2274,0.875081,2275,0.875081,2276,0.875081,2277,0.875081,2278,0.875081,2279,0.875081,2280,0.875081,2281,0.875081,2282,0.875081,2283,0.875081,2284,0.875081,2285,0.875081,2286,0.875081,2287,0.875081,2288,0.875081,2289,0.875081,2290,0.875081,2291,0.875081,2292,0.875081,2293,0.875081,2294,0.875081,2295,0.875081,2296,0.875081,2297,0.875081,2298,0.875081,2299,0.875081,2300,0.875081,2301,0.875081,2302,0.875081,2303,0.875081,2304,0.875081,2305,0.875081,2306,0.875081,2307,0.875081,2308,0.875081,2309,0.875081,2310,0.875081,2311,0.875081,2312,0.875081,2313,0.875081,2314,0.875081,2315,0.875081,2316,0.875081,2317,0.875081,2318,0.875081,2319,0.875081,2320,0.875081,2321,0.875081,2322,0.875081,2323,0.875081,2324,0.875081,2325,0.875081,2326,0.875081,2327,0.875081,2328,0.875081,2329,0.875081,2330,0.875081,2331,0.875081,2332,0.875081,2333,0.875081,2334,0.875081,2335,0.875081,2336,0.875081,2337,0.875081,2338,0.875081,2339,0.875081,2340,0.875081,2341,0.875081,2342,0.875081,2343,0.875081,2344,0.875081,2345,0.875081,2346,0.875081,2347,0.875081,2348,0.875081,2349,0.875081,2350,0.875081,2351,0.875081,2352,0.875081,2353,0.875081,2354,0.875081,2355,0.875081,2356,0.875081,2357,0.875081,2358,0.875081,2359,0.875081,2360,0.875081,2361,0.875081,2362,0.875081,2363,0.875081,2364,0.875081,2365,0.875081,2366,0.875081,2367,0.875081,2368,0.875081,2369,0.875081,2370,0.875081,2371,0.875081,2372,0.875081,2373,0.875081,2374,0.875081,2375,0.875081,2376,0.875081,2377,0.875081,2378,0.875081,2379,0.875081,2380,0.875081,2381,0.875081,2382,0.875081,2383,0.875081,2384,0.875081,2385,0.875081,2386,0.875081,2387,0.875081,2388,0.875081,2389,0.875081,2390,0.875081,2391,0.875081,2392,0.875081,2393,0.875081,2394,0.875081,2395,0.875081,2396,0.875081,2397,0.875081,2398,0.875081,2399,0.875081,2400,0.875081,2401,0.875081,2402,0.875081,2403,0.875081,2404,0.875081,2405,0.875081,2406,0.875081,2407,0.875081,2408,0.875081,2409,0.875081,2410,0.875081,2411,0.875081,2412,0.875081,2413,0.875081,2414,0.875081,2415,0.875081,2416,0.875081,2417,0.875081,2418,0.875081,2419,0.875081,2420,0.875081,2421,0.875081,2422,0.875081,2423,0.875081,2424,0.875081,2425,0.875081,2426,0.875081,2427,0.875081,2428,0.875081,2429,0.875081,2430,0.875081,2431,0.875081,2432,0.875081,2433,0.875081,2434,0.875081,2435,0.875081,2436,0.875081,2437,0.875081,2438,0.875081,2439,0.875081,2440,0.875081,2441,0.875081,2442,0.875081,2443,0.875081,2444,0.875081,2445,0.875081,2446,0.875081,2447,0.875081,2448,0.875081,2449,0.875081,2450,0.875081,2451,0.875081,2452,0.875081,2453,0.875081,2454,0.875081,2455,0.875081,2456,0.875081,2457,0.875081,2458,0.875081,2459,0.875081,2460,0.875081,2461,0.875081,2462,0.875081,2463,0.875081,2464,0.875081,2465,0.875081,2466,0.875081,2467,0.875081,2468,0.875081,2469,0.875081,2470,0.875081,2471,0.875081,2472,0.875081,2473,0.875081,2474,0.875081,2475,0.875081,2476,0.875081,2477,0.875081,2478,0.875081,2479,0.875081,2480,0.875081,2481,0.875081,2482,0.875081,2483,0.875081,2484,0.875081,2485,0.875081,2486,0.875081,2487,0.875081,2488,0.875081,2489,0.875081,2490,0.875081,2491,0.875081,2492,0.875081,2493,0.875081,2494,0.875081,2495,0.875081,2496,0.875081,2497,0.875081,2498,0.875081,2499,0.875081,2500,0.875081,2501,0.875081,2502,0.875081,2503,0.875081,2504,0.875081,2505,0.875081,2506,0.875081,2507,0.875081,2508,0.875081,2509,0.875081,2510,0.875081,2511,0.875081,2512,0.875081,2513,0.875081,2514,0.875081,2515,0.875081,2516,0.875081,2517,0.875081,2518,0.875081,2519,0.875081,2520,0.875081,2521,0.875081,2522,0.875081,2523,0.875081,2524,0.875081,2525,0.875081,2526,0.875081,2527,0.875081,2528,0.875081,2529,0.875081,2530,0.875081,2531,0.875081,2532,0.875081,2533,0.875081,2534,0.875081,2535,0.875081,2536,0.875081,2537,0.875081,2538,0.875081,2539,0.875081,2540,0.875081,2541,0.875081,2542,0.875081,2543,0.875081,2544,0.875081,2545,0.875081,2546,0.875081,2547,0.875081,2548,0.875081,2549,0.875081,2550,0.875081,2551,0.875081,2552,0.875081,2553,0.875081,2554,0.875081,2555,0.875081,2556,0.875081,2557,0.875081,2558,0.875081,2559,0.875081,2560,0.875081,2561,0.875081,2562,0.875081,2563,0.875081,2564,0.875081,2565,0.875081,2566,0.875081,2567,0.875081,2568,0.875081,2569,0.875081,2570,0.875081,2571,0.875081,2572,0.875081,2573,0.875081,2574,0.875081,2575,0.875081,2576,0.875081,2577,0.875081,2578,0.875081,2579,0.875081,2580,0.875081,2581,0.875081,2582,0.875081,2583,0.875081,2584,0.875081,2585,0.875081,2586,0.875081,2587,0.875081,2588,0.875081,2589,0.875081,2590,0.875081,2591,0.875081,2592,0.875081,2593,0.875081,2594,0.875081,2595,0.875081,2596,0.875081,2597,0.875081,2598,0.875081,2599,0.875081,2600,0.875081,2601,0.875081,2602,0.875081,2603,0.875081,2604,0.875081)
.param VSH=table(run,1,-0.3,2,-0.3,3,-0.3,4,-0.3,5,-0.3,6,-0.3,7,-0.3,8,-0.3,9,-0.3,10,-0.3,11,-0.3,12,-0.3,13,-0.28,14,-0.28,15,-0.28,16,-0.28,17,-0.28,18,-0.28,19,-0.28,20,-0.28,21,-0.28,22,-0.28,23,-0.28,24,-0.28,25,-0.26,26,-0.26,27,-0.26,28,-0.26,29,-0.26,30,-0.26,31,-0.26,32,-0.26,33,-0.26,34,-0.26,35,-0.26,36,-0.26,37,-0.24,38,-0.24,39,-0.24,40,-0.24,41,-0.24,42,-0.24,43,-0.24,44,-0.24,45,-0.24,46,-0.24,47,-0.24,48,-0.24,49,-0.22,50,-0.22,51,-0.22,52,-0.22,53,-0.22,54,-0.22,55,-0.22,56,-0.22,57,-0.22,58,-0.22,59,-0.22,60,-0.22,61,-0.2,62,-0.2,63,-0.2,64,-0.2,65,-0.2,66,-0.2,67,-0.2,68,-0.2,69,-0.2,70,-0.2,71,-0.2,72,-0.2,73,-0.18,74,-0.18,75,-0.18,76,-0.18,77,-0.18,78,-0.18,79,-0.18,80,-0.18,81,-0.18,82,-0.18,83,-0.18,84,-0.18,85,-0.16,86,-0.16,87,-0.16,88,-0.16,89,-0.16,90,-0.16,91,-0.16,92,-0.16,93,-0.16,94,-0.16,95,-0.16,96,-0.16,97,-0.14,98,-0.14,99,-0.14,100,-0.14,101,-0.14,102,-0.14,103,-0.14,104,-0.14,105,-0.14,106,-0.14,107,-0.14,108,-0.14,109,-0.12,110,-0.12,111,-0.12,112,-0.12,113,-0.12,114,-0.12,115,-0.12,116,-0.12,117,-0.12,118,-0.12,119,-0.12,120,-0.12,121,-0.1,122,-0.1,123,-0.1,124,-0.1,125,-0.1,126,-0.1,127,-0.1,128,-0.1,129,-0.1,130,-0.1,131,-0.1,132,-0.1,133,-0.08,134,-0.08,135,-0.08,136,-0.08,137,-0.08,138,-0.08,139,-0.08,140,-0.08,141,-0.08,142,-0.08,143,-0.08,144,-0.08,145,-0.06,146,-0.06,147,-0.06,148,-0.06,149,-0.06,150,-0.06,151,-0.06,152,-0.06,153,-0.06,154,-0.06,155,-0.06,156,-0.06,157,-0.04,158,-0.04,159,-0.04,160,-0.04,161,-0.04,162,-0.04,163,-0.04,164,-0.04,165,-0.04,166,-0.04,167,-0.04,168,-0.04,169,-0.02,170,-0.02,171,-0.02,172,-0.02,173,-0.02,174,-0.02,175,-0.02,176,-0.02,177,-0.02,178,-0.02,179,-0.02,180,-0.02,181,0,182,0,183,0,184,0,185,0,186,0,187,0,188,0,189,0,190,0,191,0,192,0,193,0.02,194,0.02,195,0.02,196,0.02,197,0.02,198,0.02,199,0.02,200,0.02,201,0.02,202,0.02,203,0.02,204,0.02,205,0.04,206,0.04,207,0.04,208,0.04,209,0.04,210,0.04,211,0.04,212,0.04,213,0.04,214,0.04,215,0.04,216,0.04,217,0.06,218,0.06,219,0.06,220,0.06,221,0.06,222,0.06,223,0.06,224,0.06,225,0.06,226,0.06,227,0.06,228,0.06,229,0.08,230,0.08,231,0.08,232,0.08,233,0.08,234,0.08,235,0.08,236,0.08,237,0.08,238,0.08,239,0.08,240,0.08,241,0.1,242,0.1,243,0.1,244,0.1,245,0.1,246,0.1,247,0.1,248,0.1,249,0.1,250,0.1,251,0.1,252,0.1,253,0.12,254,0.12,255,0.12,256,0.12,257,0.12,258,0.12,259,0.12,260,0.12,261,0.12,262,0.12,263,0.12,264,0.12,265,0.14,266,0.14,267,0.14,268,0.14,269,0.14,270,0.14,271,0.14,272,0.14,273,0.14,274,0.14,275,0.14,276,0.14,277,0.16,278,0.16,279,0.16,280,0.16,281,0.16,282,0.16,283,0.16,284,0.16,285,0.16,286,0.16,287,0.16,288,0.16,289,0.18,290,0.18,291,0.18,292,0.18,293,0.18,294,0.18,295,0.18,296,0.18,297,0.18,298,0.18,299,0.18,300,0.18,301,0.2,302,0.2,303,0.2,304,0.2,305,0.2,306,0.2,307,0.2,308,0.2,309,0.2,310,0.2,311,0.2,312,0.2,313,0.22,314,0.22,315,0.22,316,0.22,317,0.22,318,0.22,319,0.22,320,0.22,321,0.22,322,0.22,323,0.22,324,0.22,325,0.24,326,0.24,327,0.24,328,0.24,329,0.24,330,0.24,331,0.24,332,0.24,333,0.24,334,0.24,335,0.24,336,0.24,337,0.26,338,0.26,339,0.26,340,0.26,341,0.26,342,0.26,343,0.26,344,0.26,345,0.26,346,0.26,347,0.26,348,0.26,349,0.28,350,0.28,351,0.28,352,0.28,353,0.28,354,0.28,355,0.28,356,0.28,357,0.28,358,0.28,359,0.28,360,0.28,361,0.3,362,0.3,363,0.3,364,0.3,365,0.3,366,0.3,367,0.3,368,0.3,369,0.3,370,0.3,371,0.3,372,0.3,373,-0.3,374,-0.3,375,-0.3,376,-0.3,377,-0.3,378,-0.3,379,-0.3,380,-0.3,381,-0.3,382,-0.3,383,-0.3,384,-0.3,385,-0.28,386,-0.28,387,-0.28,388,-0.28,389,-0.28,390,-0.28,391,-0.28,392,-0.28,393,-0.28,394,-0.28,395,-0.28,396,-0.28,397,-0.26,398,-0.26,399,-0.26,400,-0.26,401,-0.26,402,-0.26,403,-0.26,404,-0.26,405,-0.26,406,-0.26,407,-0.26,408,-0.26,409,-0.24,410,-0.24,411,-0.24,412,-0.24,413,-0.24,414,-0.24,415,-0.24,416,-0.24,417,-0.24,418,-0.24,419,-0.24,420,-0.24,421,-0.22,422,-0.22,423,-0.22,424,-0.22,425,-0.22,426,-0.22,427,-0.22,428,-0.22,429,-0.22,430,-0.22,431,-0.22,432,-0.22,433,-0.2,434,-0.2,435,-0.2,436,-0.2,437,-0.2,438,-0.2,439,-0.2,440,-0.2,441,-0.2,442,-0.2,443,-0.2,444,-0.2,445,-0.18,446,-0.18,447,-0.18,448,-0.18,449,-0.18,450,-0.18,451,-0.18,452,-0.18,453,-0.18,454,-0.18,455,-0.18,456,-0.18,457,-0.16,458,-0.16,459,-0.16,460,-0.16,461,-0.16,462,-0.16,463,-0.16,464,-0.16,465,-0.16,466,-0.16,467,-0.16,468,-0.16,469,-0.14,470,-0.14,471,-0.14,472,-0.14,473,-0.14,474,-0.14,475,-0.14,476,-0.14,477,-0.14,478,-0.14,479,-0.14,480,-0.14,481,-0.12,482,-0.12,483,-0.12,484,-0.12,485,-0.12,486,-0.12,487,-0.12,488,-0.12,489,-0.12,490,-0.12,491,-0.12,492,-0.12,493,-0.1,494,-0.1,495,-0.1,496,-0.1,497,-0.1,498,-0.1,499,-0.1,500,-0.1,501,-0.1,502,-0.1,503,-0.1,504,-0.1,505,-0.08,506,-0.08,507,-0.08,508,-0.08,509,-0.08,510,-0.08,511,-0.08,512,-0.08,513,-0.08,514,-0.08,515,-0.08,516,-0.08,517,-0.06,518,-0.06,519,-0.06,520,-0.06,521,-0.06,522,-0.06,523,-0.06,524,-0.06,525,-0.06,526,-0.06,527,-0.06,528,-0.06,529,-0.04,530,-0.04,531,-0.04,532,-0.04,533,-0.04,534,-0.04,535,-0.04,536,-0.04,537,-0.04,538,-0.04,539,-0.04,540,-0.04,541,-0.02,542,-0.02,543,-0.02,544,-0.02,545,-0.02,546,-0.02,547,-0.02,548,-0.02,549,-0.02,550,-0.02,551,-0.02,552,-0.02,553,0,554,0,555,0,556,0,557,0,558,0,559,0,560,0,561,0,562,0,563,0,564,0,565,0.02,566,0.02,567,0.02,568,0.02,569,0.02,570,0.02,571,0.02,572,0.02,573,0.02,574,0.02,575,0.02,576,0.02,577,0.04,578,0.04,579,0.04,580,0.04,581,0.04,582,0.04,583,0.04,584,0.04,585,0.04,586,0.04,587,0.04,588,0.04,589,0.06,590,0.06,591,0.06,592,0.06,593,0.06,594,0.06,595,0.06,596,0.06,597,0.06,598,0.06,599,0.06,600,0.06,601,0.08,602,0.08,603,0.08,604,0.08,605,0.08,606,0.08,607,0.08,608,0.08,609,0.08,610,0.08,611,0.08,612,0.08,613,0.1,614,0.1,615,0.1,616,0.1,617,0.1,618,0.1,619,0.1,620,0.1,621,0.1,622,0.1,623,0.1,624,0.1,625,0.12,626,0.12,627,0.12,628,0.12,629,0.12,630,0.12,631,0.12,632,0.12,633,0.12,634,0.12,635,0.12,636,0.12,637,0.14,638,0.14,639,0.14,640,0.14,641,0.14,642,0.14,643,0.14,644,0.14,645,0.14,646,0.14,647,0.14,648,0.14,649,0.16,650,0.16,651,0.16,652,0.16,653,0.16,654,0.16,655,0.16,656,0.16,657,0.16,658,0.16,659,0.16,660,0.16,661,0.18,662,0.18,663,0.18,664,0.18,665,0.18,666,0.18,667,0.18,668,0.18,669,0.18,670,0.18,671,0.18,672,0.18,673,0.2,674,0.2,675,0.2,676,0.2,677,0.2,678,0.2,679,0.2,680,0.2,681,0.2,682,0.2,683,0.2,684,0.2,685,0.22,686,0.22,687,0.22,688,0.22,689,0.22,690,0.22,691,0.22,692,0.22,693,0.22,694,0.22,695,0.22,696,0.22,697,0.24,698,0.24,699,0.24,700,0.24,701,0.24,702,0.24,703,0.24,704,0.24,705,0.24,706,0.24,707,0.24,708,0.24,709,0.26,710,0.26,711,0.26,712,0.26,713,0.26,714,0.26,715,0.26,716,0.26,717,0.26,718,0.26,719,0.26,720,0.26,721,0.28,722,0.28,723,0.28,724,0.28,725,0.28,726,0.28,727,0.28,728,0.28,729,0.28,730,0.28,731,0.28,732,0.28,733,0.3,734,0.3,735,0.3,736,0.3,737,0.3,738,0.3,739,0.3,740,0.3,741,0.3,742,0.3,743,0.3,744,0.3,745,-0.3,746,-0.3,747,-0.3,748,-0.3,749,-0.3,750,-0.3,751,-0.3,752,-0.3,753,-0.3,754,-0.3,755,-0.3,756,-0.3,757,-0.28,758,-0.28,759,-0.28,760,-0.28,761,-0.28,762,-0.28,763,-0.28,764,-0.28,765,-0.28,766,-0.28,767,-0.28,768,-0.28,769,-0.26,770,-0.26,771,-0.26,772,-0.26,773,-0.26,774,-0.26,775,-0.26,776,-0.26,777,-0.26,778,-0.26,779,-0.26,780,-0.26,781,-0.24,782,-0.24,783,-0.24,784,-0.24,785,-0.24,786,-0.24,787,-0.24,788,-0.24,789,-0.24,790,-0.24,791,-0.24,792,-0.24,793,-0.22,794,-0.22,795,-0.22,796,-0.22,797,-0.22,798,-0.22,799,-0.22,800,-0.22,801,-0.22,802,-0.22,803,-0.22,804,-0.22,805,-0.2,806,-0.2,807,-0.2,808,-0.2,809,-0.2,810,-0.2,811,-0.2,812,-0.2,813,-0.2,814,-0.2,815,-0.2,816,-0.2,817,-0.18,818,-0.18,819,-0.18,820,-0.18,821,-0.18,822,-0.18,823,-0.18,824,-0.18,825,-0.18,826,-0.18,827,-0.18,828,-0.18,829,-0.16,830,-0.16,831,-0.16,832,-0.16,833,-0.16,834,-0.16,835,-0.16,836,-0.16,837,-0.16,838,-0.16,839,-0.16,840,-0.16,841,-0.14,842,-0.14,843,-0.14,844,-0.14,845,-0.14,846,-0.14,847,-0.14,848,-0.14,849,-0.14,850,-0.14,851,-0.14,852,-0.14,853,-0.12,854,-0.12,855,-0.12,856,-0.12,857,-0.12,858,-0.12,859,-0.12,860,-0.12,861,-0.12,862,-0.12,863,-0.12,864,-0.12,865,-0.1,866,-0.1,867,-0.1,868,-0.1,869,-0.1,870,-0.1,871,-0.1,872,-0.1,873,-0.1,874,-0.1,875,-0.1,876,-0.1,877,-0.08,878,-0.08,879,-0.08,880,-0.08,881,-0.08,882,-0.08,883,-0.08,884,-0.08,885,-0.08,886,-0.08,887,-0.08,888,-0.08,889,-0.06,890,-0.06,891,-0.06,892,-0.06,893,-0.06,894,-0.06,895,-0.06,896,-0.06,897,-0.06,898,-0.06,899,-0.06,900,-0.06,901,-0.04,902,-0.04,903,-0.04,904,-0.04,905,-0.04,906,-0.04,907,-0.04,908,-0.04,909,-0.04,910,-0.04,911,-0.04,912,-0.04,913,-0.02,914,-0.02,915,-0.02,916,-0.02,917,-0.02,918,-0.02,919,-0.02,920,-0.02,921,-0.02,922,-0.02,923,-0.02,924,-0.02,925,0,926,0,927,0,928,0,929,0,930,0,931,0,932,0,933,0,934,0,935,0,936,0,937,0.02,938,0.02,939,0.02,940,0.02,941,0.02,942,0.02,943,0.02,944,0.02,945,0.02,946,0.02,947,0.02,948,0.02,949,0.04,950,0.04,951,0.04,952,0.04,953,0.04,954,0.04,955,0.04,956,0.04,957,0.04,958,0.04,959,0.04,960,0.04,961,0.06,962,0.06,963,0.06,964,0.06,965,0.06,966,0.06,967,0.06,968,0.06,969,0.06,970,0.06,971,0.06,972,0.06,973,0.08,974,0.08,975,0.08,976,0.08,977,0.08,978,0.08,979,0.08,980,0.08,981,0.08,982,0.08,983,0.08,984,0.08,985,0.1,986,0.1,987,0.1,988,0.1,989,0.1,990,0.1,991,0.1,992,0.1,993,0.1,994,0.1,995,0.1,996,0.1,997,0.12,998,0.12,999,0.12,1000,0.12,1001,0.12,1002,0.12,1003,0.12,1004,0.12,1005,0.12,1006,0.12,1007,0.12,1008,0.12,1009,0.14,1010,0.14,1011,0.14,1012,0.14,1013,0.14,1014,0.14,1015,0.14,1016,0.14,1017,0.14,1018,0.14,1019,0.14,1020,0.14,1021,0.16,1022,0.16,1023,0.16,1024,0.16,1025,0.16,1026,0.16,1027,0.16,1028,0.16,1029,0.16,1030,0.16,1031,0.16,1032,0.16,1033,0.18,1034,0.18,1035,0.18,1036,0.18,1037,0.18,1038,0.18,1039,0.18,1040,0.18,1041,0.18,1042,0.18,1043,0.18,1044,0.18,1045,0.2,1046,0.2,1047,0.2,1048,0.2,1049,0.2,1050,0.2,1051,0.2,1052,0.2,1053,0.2,1054,0.2,1055,0.2,1056,0.2,1057,0.22,1058,0.22,1059,0.22,1060,0.22,1061,0.22,1062,0.22,1063,0.22,1064,0.22,1065,0.22,1066,0.22,1067,0.22,1068,0.22,1069,0.24,1070,0.24,1071,0.24,1072,0.24,1073,0.24,1074,0.24,1075,0.24,1076,0.24,1077,0.24,1078,0.24,1079,0.24,1080,0.24,1081,0.26,1082,0.26,1083,0.26,1084,0.26,1085,0.26,1086,0.26,1087,0.26,1088,0.26,1089,0.26,1090,0.26,1091,0.26,1092,0.26,1093,0.28,1094,0.28,1095,0.28,1096,0.28,1097,0.28,1098,0.28,1099,0.28,1100,0.28,1101,0.28,1102,0.28,1103,0.28,1104,0.28,1105,0.3,1106,0.3,1107,0.3,1108,0.3,1109,0.3,1110,0.3,1111,0.3,1112,0.3,1113,0.3,1114,0.3,1115,0.3,1116,0.3,1117,-0.3,1118,-0.3,1119,-0.3,1120,-0.3,1121,-0.3,1122,-0.3,1123,-0.3,1124,-0.3,1125,-0.3,1126,-0.3,1127,-0.3,1128,-0.3,1129,-0.28,1130,-0.28,1131,-0.28,1132,-0.28,1133,-0.28,1134,-0.28,1135,-0.28,1136,-0.28,1137,-0.28,1138,-0.28,1139,-0.28,1140,-0.28,1141,-0.26,1142,-0.26,1143,-0.26,1144,-0.26,1145,-0.26,1146,-0.26,1147,-0.26,1148,-0.26,1149,-0.26,1150,-0.26,1151,-0.26,1152,-0.26,1153,-0.24,1154,-0.24,1155,-0.24,1156,-0.24,1157,-0.24,1158,-0.24,1159,-0.24,1160,-0.24,1161,-0.24,1162,-0.24,1163,-0.24,1164,-0.24,1165,-0.22,1166,-0.22,1167,-0.22,1168,-0.22,1169,-0.22,1170,-0.22,1171,-0.22,1172,-0.22,1173,-0.22,1174,-0.22,1175,-0.22,1176,-0.22,1177,-0.2,1178,-0.2,1179,-0.2,1180,-0.2,1181,-0.2,1182,-0.2,1183,-0.2,1184,-0.2,1185,-0.2,1186,-0.2,1187,-0.2,1188,-0.2,1189,-0.18,1190,-0.18,1191,-0.18,1192,-0.18,1193,-0.18,1194,-0.18,1195,-0.18,1196,-0.18,1197,-0.18,1198,-0.18,1199,-0.18,1200,-0.18,1201,-0.16,1202,-0.16,1203,-0.16,1204,-0.16,1205,-0.16,1206,-0.16,1207,-0.16,1208,-0.16,1209,-0.16,1210,-0.16,1211,-0.16,1212,-0.16,1213,-0.14,1214,-0.14,1215,-0.14,1216,-0.14,1217,-0.14,1218,-0.14,1219,-0.14,1220,-0.14,1221,-0.14,1222,-0.14,1223,-0.14,1224,-0.14,1225,-0.12,1226,-0.12,1227,-0.12,1228,-0.12,1229,-0.12,1230,-0.12,1231,-0.12,1232,-0.12,1233,-0.12,1234,-0.12,1235,-0.12,1236,-0.12,1237,-0.1,1238,-0.1,1239,-0.1,1240,-0.1,1241,-0.1,1242,-0.1,1243,-0.1,1244,-0.1,1245,-0.1,1246,-0.1,1247,-0.1,1248,-0.1,1249,-0.08,1250,-0.08,1251,-0.08,1252,-0.08,1253,-0.08,1254,-0.08,1255,-0.08,1256,-0.08,1257,-0.08,1258,-0.08,1259,-0.08,1260,-0.08,1261,-0.06,1262,-0.06,1263,-0.06,1264,-0.06,1265,-0.06,1266,-0.06,1267,-0.06,1268,-0.06,1269,-0.06,1270,-0.06,1271,-0.06,1272,-0.06,1273,-0.04,1274,-0.04,1275,-0.04,1276,-0.04,1277,-0.04,1278,-0.04,1279,-0.04,1280,-0.04,1281,-0.04,1282,-0.04,1283,-0.04,1284,-0.04,1285,-0.02,1286,-0.02,1287,-0.02,1288,-0.02,1289,-0.02,1290,-0.02,1291,-0.02,1292,-0.02,1293,-0.02,1294,-0.02,1295,-0.02,1296,-0.02,1297,0,1298,0,1299,0,1300,0,1301,0,1302,0,1303,0,1304,0,1305,0,1306,0,1307,0,1308,0,1309,0.02,1310,0.02,1311,0.02,1312,0.02,1313,0.02,1314,0.02,1315,0.02,1316,0.02,1317,0.02,1318,0.02,1319,0.02,1320,0.02,1321,0.04,1322,0.04,1323,0.04,1324,0.04,1325,0.04,1326,0.04,1327,0.04,1328,0.04,1329,0.04,1330,0.04,1331,0.04,1332,0.04,1333,0.06,1334,0.06,1335,0.06,1336,0.06,1337,0.06,1338,0.06,1339,0.06,1340,0.06,1341,0.06,1342,0.06,1343,0.06,1344,0.06,1345,0.08,1346,0.08,1347,0.08,1348,0.08,1349,0.08,1350,0.08,1351,0.08,1352,0.08,1353,0.08,1354,0.08,1355,0.08,1356,0.08,1357,0.1,1358,0.1,1359,0.1,1360,0.1,1361,0.1,1362,0.1,1363,0.1,1364,0.1,1365,0.1,1366,0.1,1367,0.1,1368,0.1,1369,0.12,1370,0.12,1371,0.12,1372,0.12,1373,0.12,1374,0.12,1375,0.12,1376,0.12,1377,0.12,1378,0.12,1379,0.12,1380,0.12,1381,0.14,1382,0.14,1383,0.14,1384,0.14,1385,0.14,1386,0.14,1387,0.14,1388,0.14,1389,0.14,1390,0.14,1391,0.14,1392,0.14,1393,0.16,1394,0.16,1395,0.16,1396,0.16,1397,0.16,1398,0.16,1399,0.16,1400,0.16,1401,0.16,1402,0.16,1403,0.16,1404,0.16,1405,0.18,1406,0.18,1407,0.18,1408,0.18,1409,0.18,1410,0.18,1411,0.18,1412,0.18,1413,0.18,1414,0.18,1415,0.18,1416,0.18,1417,0.2,1418,0.2,1419,0.2,1420,0.2,1421,0.2,1422,0.2,1423,0.2,1424,0.2,1425,0.2,1426,0.2,1427,0.2,1428,0.2,1429,0.22,1430,0.22,1431,0.22,1432,0.22,1433,0.22,1434,0.22,1435,0.22,1436,0.22,1437,0.22,1438,0.22,1439,0.22,1440,0.22,1441,0.24,1442,0.24,1443,0.24,1444,0.24,1445,0.24,1446,0.24,1447,0.24,1448,0.24,1449,0.24,1450,0.24,1451,0.24,1452,0.24,1453,0.26,1454,0.26,1455,0.26,1456,0.26,1457,0.26,1458,0.26,1459,0.26,1460,0.26,1461,0.26,1462,0.26,1463,0.26,1464,0.26,1465,0.28,1466,0.28,1467,0.28,1468,0.28,1469,0.28,1470,0.28,1471,0.28,1472,0.28,1473,0.28,1474,0.28,1475,0.28,1476,0.28,1477,0.3,1478,0.3,1479,0.3,1480,0.3,1481,0.3,1482,0.3,1483,0.3,1484,0.3,1485,0.3,1486,0.3,1487,0.3,1488,0.3,1489,-0.3,1490,-0.3,1491,-0.3,1492,-0.3,1493,-0.3,1494,-0.3,1495,-0.3,1496,-0.3,1497,-0.3,1498,-0.3,1499,-0.3,1500,-0.3,1501,-0.28,1502,-0.28,1503,-0.28,1504,-0.28,1505,-0.28,1506,-0.28,1507,-0.28,1508,-0.28,1509,-0.28,1510,-0.28,1511,-0.28,1512,-0.28,1513,-0.26,1514,-0.26,1515,-0.26,1516,-0.26,1517,-0.26,1518,-0.26,1519,-0.26,1520,-0.26,1521,-0.26,1522,-0.26,1523,-0.26,1524,-0.26,1525,-0.24,1526,-0.24,1527,-0.24,1528,-0.24,1529,-0.24,1530,-0.24,1531,-0.24,1532,-0.24,1533,-0.24,1534,-0.24,1535,-0.24,1536,-0.24,1537,-0.22,1538,-0.22,1539,-0.22,1540,-0.22,1541,-0.22,1542,-0.22,1543,-0.22,1544,-0.22,1545,-0.22,1546,-0.22,1547,-0.22,1548,-0.22,1549,-0.2,1550,-0.2,1551,-0.2,1552,-0.2,1553,-0.2,1554,-0.2,1555,-0.2,1556,-0.2,1557,-0.2,1558,-0.2,1559,-0.2,1560,-0.2,1561,-0.18,1562,-0.18,1563,-0.18,1564,-0.18,1565,-0.18,1566,-0.18,1567,-0.18,1568,-0.18,1569,-0.18,1570,-0.18,1571,-0.18,1572,-0.18,1573,-0.16,1574,-0.16,1575,-0.16,1576,-0.16,1577,-0.16,1578,-0.16,1579,-0.16,1580,-0.16,1581,-0.16,1582,-0.16,1583,-0.16,1584,-0.16,1585,-0.14,1586,-0.14,1587,-0.14,1588,-0.14,1589,-0.14,1590,-0.14,1591,-0.14,1592,-0.14,1593,-0.14,1594,-0.14,1595,-0.14,1596,-0.14,1597,-0.12,1598,-0.12,1599,-0.12,1600,-0.12,1601,-0.12,1602,-0.12,1603,-0.12,1604,-0.12,1605,-0.12,1606,-0.12,1607,-0.12,1608,-0.12,1609,-0.1,1610,-0.1,1611,-0.1,1612,-0.1,1613,-0.1,1614,-0.1,1615,-0.1,1616,-0.1,1617,-0.1,1618,-0.1,1619,-0.1,1620,-0.1,1621,-0.08,1622,-0.08,1623,-0.08,1624,-0.08,1625,-0.08,1626,-0.08,1627,-0.08,1628,-0.08,1629,-0.08,1630,-0.08,1631,-0.08,1632,-0.08,1633,-0.06,1634,-0.06,1635,-0.06,1636,-0.06,1637,-0.06,1638,-0.06,1639,-0.06,1640,-0.06,1641,-0.06,1642,-0.06,1643,-0.06,1644,-0.06,1645,-0.04,1646,-0.04,1647,-0.04,1648,-0.04,1649,-0.04,1650,-0.04,1651,-0.04,1652,-0.04,1653,-0.04,1654,-0.04,1655,-0.04,1656,-0.04,1657,-0.02,1658,-0.02,1659,-0.02,1660,-0.02,1661,-0.02,1662,-0.02,1663,-0.02,1664,-0.02,1665,-0.02,1666,-0.02,1667,-0.02,1668,-0.02,1669,0,1670,0,1671,0,1672,0,1673,0,1674,0,1675,0,1676,0,1677,0,1678,0,1679,0,1680,0,1681,0.02,1682,0.02,1683,0.02,1684,0.02,1685,0.02,1686,0.02,1687,0.02,1688,0.02,1689,0.02,1690,0.02,1691,0.02,1692,0.02,1693,0.04,1694,0.04,1695,0.04,1696,0.04,1697,0.04,1698,0.04,1699,0.04,1700,0.04,1701,0.04,1702,0.04,1703,0.04,1704,0.04,1705,0.06,1706,0.06,1707,0.06,1708,0.06,1709,0.06,1710,0.06,1711,0.06,1712,0.06,1713,0.06,1714,0.06,1715,0.06,1716,0.06,1717,0.08,1718,0.08,1719,0.08,1720,0.08,1721,0.08,1722,0.08,1723,0.08,1724,0.08,1725,0.08,1726,0.08,1727,0.08,1728,0.08,1729,0.1,1730,0.1,1731,0.1,1732,0.1,1733,0.1,1734,0.1,1735,0.1,1736,0.1,1737,0.1,1738,0.1,1739,0.1,1740,0.1,1741,0.12,1742,0.12,1743,0.12,1744,0.12,1745,0.12,1746,0.12,1747,0.12,1748,0.12,1749,0.12,1750,0.12,1751,0.12,1752,0.12,1753,0.14,1754,0.14,1755,0.14,1756,0.14,1757,0.14,1758,0.14,1759,0.14,1760,0.14,1761,0.14,1762,0.14,1763,0.14,1764,0.14,1765,0.16,1766,0.16,1767,0.16,1768,0.16,1769,0.16,1770,0.16,1771,0.16,1772,0.16,1773,0.16,1774,0.16,1775,0.16,1776,0.16,1777,0.18,1778,0.18,1779,0.18,1780,0.18,1781,0.18,1782,0.18,1783,0.18,1784,0.18,1785,0.18,1786,0.18,1787,0.18,1788,0.18,1789,0.2,1790,0.2,1791,0.2,1792,0.2,1793,0.2,1794,0.2,1795,0.2,1796,0.2,1797,0.2,1798,0.2,1799,0.2,1800,0.2,1801,0.22,1802,0.22,1803,0.22,1804,0.22,1805,0.22,1806,0.22,1807,0.22,1808,0.22,1809,0.22,1810,0.22,1811,0.22,1812,0.22,1813,0.24,1814,0.24,1815,0.24,1816,0.24,1817,0.24,1818,0.24,1819,0.24,1820,0.24,1821,0.24,1822,0.24,1823,0.24,1824,0.24,1825,0.26,1826,0.26,1827,0.26,1828,0.26,1829,0.26,1830,0.26,1831,0.26,1832,0.26,1833,0.26,1834,0.26,1835,0.26,1836,0.26,1837,0.28,1838,0.28,1839,0.28,1840,0.28,1841,0.28,1842,0.28,1843,0.28,1844,0.28,1845,0.28,1846,0.28,1847,0.28,1848,0.28,1849,0.3,1850,0.3,1851,0.3,1852,0.3,1853,0.3,1854,0.3,1855,0.3,1856,0.3,1857,0.3,1858,0.3,1859,0.3,1860,0.3,1861,-0.3,1862,-0.3,1863,-0.3,1864,-0.3,1865,-0.3,1866,-0.3,1867,-0.3,1868,-0.3,1869,-0.3,1870,-0.3,1871,-0.3,1872,-0.3,1873,-0.28,1874,-0.28,1875,-0.28,1876,-0.28,1877,-0.28,1878,-0.28,1879,-0.28,1880,-0.28,1881,-0.28,1882,-0.28,1883,-0.28,1884,-0.28,1885,-0.26,1886,-0.26,1887,-0.26,1888,-0.26,1889,-0.26,1890,-0.26,1891,-0.26,1892,-0.26,1893,-0.26,1894,-0.26,1895,-0.26,1896,-0.26,1897,-0.24,1898,-0.24,1899,-0.24,1900,-0.24,1901,-0.24,1902,-0.24,1903,-0.24,1904,-0.24,1905,-0.24,1906,-0.24,1907,-0.24,1908,-0.24,1909,-0.22,1910,-0.22,1911,-0.22,1912,-0.22,1913,-0.22,1914,-0.22,1915,-0.22,1916,-0.22,1917,-0.22,1918,-0.22,1919,-0.22,1920,-0.22,1921,-0.2,1922,-0.2,1923,-0.2,1924,-0.2,1925,-0.2,1926,-0.2,1927,-0.2,1928,-0.2,1929,-0.2,1930,-0.2,1931,-0.2,1932,-0.2,1933,-0.18,1934,-0.18,1935,-0.18,1936,-0.18,1937,-0.18,1938,-0.18,1939,-0.18,1940,-0.18,1941,-0.18,1942,-0.18,1943,-0.18,1944,-0.18,1945,-0.16,1946,-0.16,1947,-0.16,1948,-0.16,1949,-0.16,1950,-0.16,1951,-0.16,1952,-0.16,1953,-0.16,1954,-0.16,1955,-0.16,1956,-0.16,1957,-0.14,1958,-0.14,1959,-0.14,1960,-0.14,1961,-0.14,1962,-0.14,1963,-0.14,1964,-0.14,1965,-0.14,1966,-0.14,1967,-0.14,1968,-0.14,1969,-0.12,1970,-0.12,1971,-0.12,1972,-0.12,1973,-0.12,1974,-0.12,1975,-0.12,1976,-0.12,1977,-0.12,1978,-0.12,1979,-0.12,1980,-0.12,1981,-0.1,1982,-0.1,1983,-0.1,1984,-0.1,1985,-0.1,1986,-0.1,1987,-0.1,1988,-0.1,1989,-0.1,1990,-0.1,1991,-0.1,1992,-0.1,1993,-0.08,1994,-0.08,1995,-0.08,1996,-0.08,1997,-0.08,1998,-0.08,1999,-0.08,2000,-0.08,2001,-0.08,2002,-0.08,2003,-0.08,2004,-0.08,2005,-0.06,2006,-0.06,2007,-0.06,2008,-0.06,2009,-0.06,2010,-0.06,2011,-0.06,2012,-0.06,2013,-0.06,2014,-0.06,2015,-0.06,2016,-0.06,2017,-0.04,2018,-0.04,2019,-0.04,2020,-0.04,2021,-0.04,2022,-0.04,2023,-0.04,2024,-0.04,2025,-0.04,2026,-0.04,2027,-0.04,2028,-0.04,2029,-0.02,2030,-0.02,2031,-0.02,2032,-0.02,2033,-0.02,2034,-0.02,2035,-0.02,2036,-0.02,2037,-0.02,2038,-0.02,2039,-0.02,2040,-0.02,2041,0,2042,0,2043,0,2044,0,2045,0,2046,0,2047,0,2048,0,2049,0,2050,0,2051,0,2052,0,2053,0.02,2054,0.02,2055,0.02,2056,0.02,2057,0.02,2058,0.02,2059,0.02,2060,0.02,2061,0.02,2062,0.02,2063,0.02,2064,0.02,2065,0.04,2066,0.04,2067,0.04,2068,0.04,2069,0.04,2070,0.04,2071,0.04,2072,0.04,2073,0.04,2074,0.04,2075,0.04,2076,0.04,2077,0.06,2078,0.06,2079,0.06,2080,0.06,2081,0.06,2082,0.06,2083,0.06,2084,0.06,2085,0.06,2086,0.06,2087,0.06,2088,0.06,2089,0.08,2090,0.08,2091,0.08,2092,0.08,2093,0.08,2094,0.08,2095,0.08,2096,0.08,2097,0.08,2098,0.08,2099,0.08,2100,0.08,2101,0.1,2102,0.1,2103,0.1,2104,0.1,2105,0.1,2106,0.1,2107,0.1,2108,0.1,2109,0.1,2110,0.1,2111,0.1,2112,0.1,2113,0.12,2114,0.12,2115,0.12,2116,0.12,2117,0.12,2118,0.12,2119,0.12,2120,0.12,2121,0.12,2122,0.12,2123,0.12,2124,0.12,2125,0.14,2126,0.14,2127,0.14,2128,0.14,2129,0.14,2130,0.14,2131,0.14,2132,0.14,2133,0.14,2134,0.14,2135,0.14,2136,0.14,2137,0.16,2138,0.16,2139,0.16,2140,0.16,2141,0.16,2142,0.16,2143,0.16,2144,0.16,2145,0.16,2146,0.16,2147,0.16,2148,0.16,2149,0.18,2150,0.18,2151,0.18,2152,0.18,2153,0.18,2154,0.18,2155,0.18,2156,0.18,2157,0.18,2158,0.18,2159,0.18,2160,0.18,2161,0.2,2162,0.2,2163,0.2,2164,0.2,2165,0.2,2166,0.2,2167,0.2,2168,0.2,2169,0.2,2170,0.2,2171,0.2,2172,0.2,2173,0.22,2174,0.22,2175,0.22,2176,0.22,2177,0.22,2178,0.22,2179,0.22,2180,0.22,2181,0.22,2182,0.22,2183,0.22,2184,0.22,2185,0.24,2186,0.24,2187,0.24,2188,0.24,2189,0.24,2190,0.24,2191,0.24,2192,0.24,2193,0.24,2194,0.24,2195,0.24,2196,0.24,2197,0.26,2198,0.26,2199,0.26,2200,0.26,2201,0.26,2202,0.26,2203,0.26,2204,0.26,2205,0.26,2206,0.26,2207,0.26,2208,0.26,2209,0.28,2210,0.28,2211,0.28,2212,0.28,2213,0.28,2214,0.28,2215,0.28,2216,0.28,2217,0.28,2218,0.28,2219,0.28,2220,0.28,2221,0.3,2222,0.3,2223,0.3,2224,0.3,2225,0.3,2226,0.3,2227,0.3,2228,0.3,2229,0.3,2230,0.3,2231,0.3,2232,0.3,2233,-0.3,2234,-0.3,2235,-0.3,2236,-0.3,2237,-0.3,2238,-0.3,2239,-0.3,2240,-0.3,2241,-0.3,2242,-0.3,2243,-0.3,2244,-0.3,2245,-0.28,2246,-0.28,2247,-0.28,2248,-0.28,2249,-0.28,2250,-0.28,2251,-0.28,2252,-0.28,2253,-0.28,2254,-0.28,2255,-0.28,2256,-0.28,2257,-0.26,2258,-0.26,2259,-0.26,2260,-0.26,2261,-0.26,2262,-0.26,2263,-0.26,2264,-0.26,2265,-0.26,2266,-0.26,2267,-0.26,2268,-0.26,2269,-0.24,2270,-0.24,2271,-0.24,2272,-0.24,2273,-0.24,2274,-0.24,2275,-0.24,2276,-0.24,2277,-0.24,2278,-0.24,2279,-0.24,2280,-0.24,2281,-0.22,2282,-0.22,2283,-0.22,2284,-0.22,2285,-0.22,2286,-0.22,2287,-0.22,2288,-0.22,2289,-0.22,2290,-0.22,2291,-0.22,2292,-0.22,2293,-0.2,2294,-0.2,2295,-0.2,2296,-0.2,2297,-0.2,2298,-0.2,2299,-0.2,2300,-0.2,2301,-0.2,2302,-0.2,2303,-0.2,2304,-0.2,2305,-0.18,2306,-0.18,2307,-0.18,2308,-0.18,2309,-0.18,2310,-0.18,2311,-0.18,2312,-0.18,2313,-0.18,2314,-0.18,2315,-0.18,2316,-0.18,2317,-0.16,2318,-0.16,2319,-0.16,2320,-0.16,2321,-0.16,2322,-0.16,2323,-0.16,2324,-0.16,2325,-0.16,2326,-0.16,2327,-0.16,2328,-0.16,2329,-0.14,2330,-0.14,2331,-0.14,2332,-0.14,2333,-0.14,2334,-0.14,2335,-0.14,2336,-0.14,2337,-0.14,2338,-0.14,2339,-0.14,2340,-0.14,2341,-0.12,2342,-0.12,2343,-0.12,2344,-0.12,2345,-0.12,2346,-0.12,2347,-0.12,2348,-0.12,2349,-0.12,2350,-0.12,2351,-0.12,2352,-0.12,2353,-0.1,2354,-0.1,2355,-0.1,2356,-0.1,2357,-0.1,2358,-0.1,2359,-0.1,2360,-0.1,2361,-0.1,2362,-0.1,2363,-0.1,2364,-0.1,2365,-0.08,2366,-0.08,2367,-0.08,2368,-0.08,2369,-0.08,2370,-0.08,2371,-0.08,2372,-0.08,2373,-0.08,2374,-0.08,2375,-0.08,2376,-0.08,2377,-0.06,2378,-0.06,2379,-0.06,2380,-0.06,2381,-0.06,2382,-0.06,2383,-0.06,2384,-0.06,2385,-0.06,2386,-0.06,2387,-0.06,2388,-0.06,2389,-0.04,2390,-0.04,2391,-0.04,2392,-0.04,2393,-0.04,2394,-0.04,2395,-0.04,2396,-0.04,2397,-0.04,2398,-0.04,2399,-0.04,2400,-0.04,2401,-0.02,2402,-0.02,2403,-0.02,2404,-0.02,2405,-0.02,2406,-0.02,2407,-0.02,2408,-0.02,2409,-0.02,2410,-0.02,2411,-0.02,2412,-0.02,2413,0,2414,0,2415,0,2416,0,2417,0,2418,0,2419,0,2420,0,2421,0,2422,0,2423,0,2424,0,2425,0.02,2426,0.02,2427,0.02,2428,0.02,2429,0.02,2430,0.02,2431,0.02,2432,0.02,2433,0.02,2434,0.02,2435,0.02,2436,0.02,2437,0.04,2438,0.04,2439,0.04,2440,0.04,2441,0.04,2442,0.04,2443,0.04,2444,0.04,2445,0.04,2446,0.04,2447,0.04,2448,0.04,2449,0.06,2450,0.06,2451,0.06,2452,0.06,2453,0.06,2454,0.06,2455,0.06,2456,0.06,2457,0.06,2458,0.06,2459,0.06,2460,0.06,2461,0.08,2462,0.08,2463,0.08,2464,0.08,2465,0.08,2466,0.08,2467,0.08,2468,0.08,2469,0.08,2470,0.08,2471,0.08,2472,0.08,2473,0.1,2474,0.1,2475,0.1,2476,0.1,2477,0.1,2478,0.1,2479,0.1,2480,0.1,2481,0.1,2482,0.1,2483,0.1,2484,0.1,2485,0.12,2486,0.12,2487,0.12,2488,0.12,2489,0.12,2490,0.12,2491,0.12,2492,0.12,2493,0.12,2494,0.12,2495,0.12,2496,0.12,2497,0.14,2498,0.14,2499,0.14,2500,0.14,2501,0.14,2502,0.14,2503,0.14,2504,0.14,2505,0.14,2506,0.14,2507,0.14,2508,0.14,2509,0.16,2510,0.16,2511,0.16,2512,0.16,2513,0.16,2514,0.16,2515,0.16,2516,0.16,2517,0.16,2518,0.16,2519,0.16,2520,0.16,2521,0.18,2522,0.18,2523,0.18,2524,0.18,2525,0.18,2526,0.18,2527,0.18,2528,0.18,2529,0.18,2530,0.18,2531,0.18,2532,0.18,2533,0.2,2534,0.2,2535,0.2,2536,0.2,2537,0.2,2538,0.2,2539,0.2,2540,0.2,2541,0.2,2542,0.2,2543,0.2,2544,0.2,2545,0.22,2546,0.22,2547,0.22,2548,0.22,2549,0.22,2550,0.22,2551,0.22,2552,0.22,2553,0.22,2554,0.22,2555,0.22,2556,0.22,2557,0.24,2558,0.24,2559,0.24,2560,0.24,2561,0.24,2562,0.24,2563,0.24,2564,0.24,2565,0.24,2566,0.24,2567,0.24,2568,0.24,2569,0.26,2570,0.26,2571,0.26,2572,0.26,2573,0.26,2574,0.26,2575,0.26,2576,0.26,2577,0.26,2578,0.26,2579,0.26,2580,0.26,2581,0.28,2582,0.28,2583,0.28,2584,0.28,2585,0.28,2586,0.28,2587,0.28,2588,0.28,2589,0.28,2590,0.28,2591,0.28,2592,0.28,2593,0.3,2594,0.3,2595,0.3,2596,0.3,2597,0.3,2598,0.3,2599,0.3,2600,0.3,2601,0.3,2602,0.3,2603,0.3,2604,0.3)
.param VOS=table(run,1,0,2,0,3,0,4,0,5,0,6,0,7,0,8,0,9,0,10,0,11,0,12,0,13,0,14,0,15,0,16,0,17,0,18,0,19,0,20,0,21,0,22,0,23,0,24,0,25,0,26,0,27,0,28,0,29,0,30,0,31,0,32,0,33,0,34,0,35,0,36,0,37,0,38,0,39,0,40,0,41,0,42,0,43,0,44,0,45,0,46,0,47,0,48,0,49,0,50,0,51,0,52,0,53,0,54,0,55,0,56,0,57,0,58,0,59,0,60,0,61,0,62,0,63,0,64,0,65,0,66,0,67,0,68,0,69,0,70,0,71,0,72,0,73,0,74,0,75,0,76,0,77,0,78,0,79,0,80,0,81,0,82,0,83,0,84,0,85,0,86,0,87,0,88,0,89,0,90,0,91,0,92,0,93,0,94,0,95,0,96,0,97,0,98,0,99,0,100,0,101,0,102,0,103,0,104,0,105,0,106,0,107,0,108,0,109,0,110,0,111,0,112,0,113,0,114,0,115,0,116,0,117,0,118,0,119,0,120,0,121,0,122,0,123,0,124,0,125,0,126,0,127,0,128,0,129,0,130,0,131,0,132,0,133,0,134,0,135,0,136,0,137,0,138,0,139,0,140,0,141,0,142,0,143,0,144,0,145,0,146,0,147,0,148,0,149,0,150,0,151,0,152,0,153,0,154,0,155,0,156,0,157,0,158,0,159,0,160,0,161,0,162,0,163,0,164,0,165,0,166,0,167,0,168,0,169,0,170,0,171,0,172,0,173,0,174,0,175,0,176,0,177,0,178,0,179,0,180,0,181,0,182,0,183,0,184,0,185,0,186,0,187,0,188,0,189,0,190,0,191,0,192,0,193,0,194,0,195,0,196,0,197,0,198,0,199,0,200,0,201,0,202,0,203,0,204,0,205,0,206,0,207,0,208,0,209,0,210,0,211,0,212,0,213,0,214,0,215,0,216,0,217,0,218,0,219,0,220,0,221,0,222,0,223,0,224,0,225,0,226,0,227,0,228,0,229,0,230,0,231,0,232,0,233,0,234,0,235,0,236,0,237,0,238,0,239,0,240,0,241,0,242,0,243,0,244,0,245,0,246,0,247,0,248,0,249,0,250,0,251,0,252,0,253,0,254,0,255,0,256,0,257,0,258,0,259,0,260,0,261,0,262,0,263,0,264,0,265,0,266,0,267,0,268,0,269,0,270,0,271,0,272,0,273,0,274,0,275,0,276,0,277,0,278,0,279,0,280,0,281,0,282,0,283,0,284,0,285,0,286,0,287,0,288,0,289,0,290,0,291,0,292,0,293,0,294,0,295,0,296,0,297,0,298,0,299,0,300,0,301,0,302,0,303,0,304,0,305,0,306,0,307,0,308,0,309,0,310,0,311,0,312,0,313,0,314,0,315,0,316,0,317,0,318,0,319,0,320,0,321,0,322,0,323,0,324,0,325,0,326,0,327,0,328,0,329,0,330,0,331,0,332,0,333,0,334,0,335,0,336,0,337,0,338,0,339,0,340,0,341,0,342,0,343,0,344,0,345,0,346,0,347,0,348,0,349,0,350,0,351,0,352,0,353,0,354,0,355,0,356,0,357,0,358,0,359,0,360,0,361,0,362,0,363,0,364,0,365,0,366,0,367,0,368,0,369,0,370,0,371,0,372,0,373,0.001,374,0.001,375,0.001,376,0.001,377,0.001,378,0.001,379,0.001,380,0.001,381,0.001,382,0.001,383,0.001,384,0.001,385,0.001,386,0.001,387,0.001,388,0.001,389,0.001,390,0.001,391,0.001,392,0.001,393,0.001,394,0.001,395,0.001,396,0.001,397,0.001,398,0.001,399,0.001,400,0.001,401,0.001,402,0.001,403,0.001,404,0.001,405,0.001,406,0.001,407,0.001,408,0.001,409,0.001,410,0.001,411,0.001,412,0.001,413,0.001,414,0.001,415,0.001,416,0.001,417,0.001,418,0.001,419,0.001,420,0.001,421,0.001,422,0.001,423,0.001,424,0.001,425,0.001,426,0.001,427,0.001,428,0.001,429,0.001,430,0.001,431,0.001,432,0.001,433,0.001,434,0.001,435,0.001,436,0.001,437,0.001,438,0.001,439,0.001,440,0.001,441,0.001,442,0.001,443,0.001,444,0.001,445,0.001,446,0.001,447,0.001,448,0.001,449,0.001,450,0.001,451,0.001,452,0.001,453,0.001,454,0.001,455,0.001,456,0.001,457,0.001,458,0.001,459,0.001,460,0.001,461,0.001,462,0.001,463,0.001,464,0.001,465,0.001,466,0.001,467,0.001,468,0.001,469,0.001,470,0.001,471,0.001,472,0.001,473,0.001,474,0.001,475,0.001,476,0.001,477,0.001,478,0.001,479,0.001,480,0.001,481,0.001,482,0.001,483,0.001,484,0.001,485,0.001,486,0.001,487,0.001,488,0.001,489,0.001,490,0.001,491,0.001,492,0.001,493,0.001,494,0.001,495,0.001,496,0.001,497,0.001,498,0.001,499,0.001,500,0.001,501,0.001,502,0.001,503,0.001,504,0.001,505,0.001,506,0.001,507,0.001,508,0.001,509,0.001,510,0.001,511,0.001,512,0.001,513,0.001,514,0.001,515,0.001,516,0.001,517,0.001,518,0.001,519,0.001,520,0.001,521,0.001,522,0.001,523,0.001,524,0.001,525,0.001,526,0.001,527,0.001,528,0.001,529,0.001,530,0.001,531,0.001,532,0.001,533,0.001,534,0.001,535,0.001,536,0.001,537,0.001,538,0.001,539,0.001,540,0.001,541,0.001,542,0.001,543,0.001,544,0.001,545,0.001,546,0.001,547,0.001,548,0.001,549,0.001,550,0.001,551,0.001,552,0.001,553,0.001,554,0.001,555,0.001,556,0.001,557,0.001,558,0.001,559,0.001,560,0.001,561,0.001,562,0.001,563,0.001,564,0.001,565,0.001,566,0.001,567,0.001,568,0.001,569,0.001,570,0.001,571,0.001,572,0.001,573,0.001,574,0.001,575,0.001,576,0.001,577,0.001,578,0.001,579,0.001,580,0.001,581,0.001,582,0.001,583,0.001,584,0.001,585,0.001,586,0.001,587,0.001,588,0.001,589,0.001,590,0.001,591,0.001,592,0.001,593,0.001,594,0.001,595,0.001,596,0.001,597,0.001,598,0.001,599,0.001,600,0.001,601,0.001,602,0.001,603,0.001,604,0.001,605,0.001,606,0.001,607,0.001,608,0.001,609,0.001,610,0.001,611,0.001,612,0.001,613,0.001,614,0.001,615,0.001,616,0.001,617,0.001,618,0.001,619,0.001,620,0.001,621,0.001,622,0.001,623,0.001,624,0.001,625,0.001,626,0.001,627,0.001,628,0.001,629,0.001,630,0.001,631,0.001,632,0.001,633,0.001,634,0.001,635,0.001,636,0.001,637,0.001,638,0.001,639,0.001,640,0.001,641,0.001,642,0.001,643,0.001,644,0.001,645,0.001,646,0.001,647,0.001,648,0.001,649,0.001,650,0.001,651,0.001,652,0.001,653,0.001,654,0.001,655,0.001,656,0.001,657,0.001,658,0.001,659,0.001,660,0.001,661,0.001,662,0.001,663,0.001,664,0.001,665,0.001,666,0.001,667,0.001,668,0.001,669,0.001,670,0.001,671,0.001,672,0.001,673,0.001,674,0.001,675,0.001,676,0.001,677,0.001,678,0.001,679,0.001,680,0.001,681,0.001,682,0.001,683,0.001,684,0.001,685,0.001,686,0.001,687,0.001,688,0.001,689,0.001,690,0.001,691,0.001,692,0.001,693,0.001,694,0.001,695,0.001,696,0.001,697,0.001,698,0.001,699,0.001,700,0.001,701,0.001,702,0.001,703,0.001,704,0.001,705,0.001,706,0.001,707,0.001,708,0.001,709,0.001,710,0.001,711,0.001,712,0.001,713,0.001,714,0.001,715,0.001,716,0.001,717,0.001,718,0.001,719,0.001,720,0.001,721,0.001,722,0.001,723,0.001,724,0.001,725,0.001,726,0.001,727,0.001,728,0.001,729,0.001,730,0.001,731,0.001,732,0.001,733,0.001,734,0.001,735,0.001,736,0.001,737,0.001,738,0.001,739,0.001,740,0.001,741,0.001,742,0.001,743,0.001,744,0.001,745,-0.001,746,-0.001,747,-0.001,748,-0.001,749,-0.001,750,-0.001,751,-0.001,752,-0.001,753,-0.001,754,-0.001,755,-0.001,756,-0.001,757,-0.001,758,-0.001,759,-0.001,760,-0.001,761,-0.001,762,-0.001,763,-0.001,764,-0.001,765,-0.001,766,-0.001,767,-0.001,768,-0.001,769,-0.001,770,-0.001,771,-0.001,772,-0.001,773,-0.001,774,-0.001,775,-0.001,776,-0.001,777,-0.001,778,-0.001,779,-0.001,780,-0.001,781,-0.001,782,-0.001,783,-0.001,784,-0.001,785,-0.001,786,-0.001,787,-0.001,788,-0.001,789,-0.001,790,-0.001,791,-0.001,792,-0.001,793,-0.001,794,-0.001,795,-0.001,796,-0.001,797,-0.001,798,-0.001,799,-0.001,800,-0.001,801,-0.001,802,-0.001,803,-0.001,804,-0.001,805,-0.001,806,-0.001,807,-0.001,808,-0.001,809,-0.001,810,-0.001,811,-0.001,812,-0.001,813,-0.001,814,-0.001,815,-0.001,816,-0.001,817,-0.001,818,-0.001,819,-0.001,820,-0.001,821,-0.001,822,-0.001,823,-0.001,824,-0.001,825,-0.001,826,-0.001,827,-0.001,828,-0.001,829,-0.001,830,-0.001,831,-0.001,832,-0.001,833,-0.001,834,-0.001,835,-0.001,836,-0.001,837,-0.001,838,-0.001,839,-0.001,840,-0.001,841,-0.001,842,-0.001,843,-0.001,844,-0.001,845,-0.001,846,-0.001,847,-0.001,848,-0.001,849,-0.001,850,-0.001,851,-0.001,852,-0.001,853,-0.001,854,-0.001,855,-0.001,856,-0.001,857,-0.001,858,-0.001,859,-0.001,860,-0.001,861,-0.001,862,-0.001,863,-0.001,864,-0.001,865,-0.001,866,-0.001,867,-0.001,868,-0.001,869,-0.001,870,-0.001,871,-0.001,872,-0.001,873,-0.001,874,-0.001,875,-0.001,876,-0.001,877,-0.001,878,-0.001,879,-0.001,880,-0.001,881,-0.001,882,-0.001,883,-0.001,884,-0.001,885,-0.001,886,-0.001,887,-0.001,888,-0.001,889,-0.001,890,-0.001,891,-0.001,892,-0.001,893,-0.001,894,-0.001,895,-0.001,896,-0.001,897,-0.001,898,-0.001,899,-0.001,900,-0.001,901,-0.001,902,-0.001,903,-0.001,904,-0.001,905,-0.001,906,-0.001,907,-0.001,908,-0.001,909,-0.001,910,-0.001,911,-0.001,912,-0.001,913,-0.001,914,-0.001,915,-0.001,916,-0.001,917,-0.001,918,-0.001,919,-0.001,920,-0.001,921,-0.001,922,-0.001,923,-0.001,924,-0.001,925,-0.001,926,-0.001,927,-0.001,928,-0.001,929,-0.001,930,-0.001,931,-0.001,932,-0.001,933,-0.001,934,-0.001,935,-0.001,936,-0.001,937,-0.001,938,-0.001,939,-0.001,940,-0.001,941,-0.001,942,-0.001,943,-0.001,944,-0.001,945,-0.001,946,-0.001,947,-0.001,948,-0.001,949,-0.001,950,-0.001,951,-0.001,952,-0.001,953,-0.001,954,-0.001,955,-0.001,956,-0.001,957,-0.001,958,-0.001,959,-0.001,960,-0.001,961,-0.001,962,-0.001,963,-0.001,964,-0.001,965,-0.001,966,-0.001,967,-0.001,968,-0.001,969,-0.001,970,-0.001,971,-0.001,972,-0.001,973,-0.001,974,-0.001,975,-0.001,976,-0.001,977,-0.001,978,-0.001,979,-0.001,980,-0.001,981,-0.001,982,-0.001,983,-0.001,984,-0.001,985,-0.001,986,-0.001,987,-0.001,988,-0.001,989,-0.001,990,-0.001,991,-0.001,992,-0.001,993,-0.001,994,-0.001,995,-0.001,996,-0.001,997,-0.001,998,-0.001,999,-0.001,1000,-0.001,1001,-0.001,1002,-0.001,1003,-0.001,1004,-0.001,1005,-0.001,1006,-0.001,1007,-0.001,1008,-0.001,1009,-0.001,1010,-0.001,1011,-0.001,1012,-0.001,1013,-0.001,1014,-0.001,1015,-0.001,1016,-0.001,1017,-0.001,1018,-0.001,1019,-0.001,1020,-0.001,1021,-0.001,1022,-0.001,1023,-0.001,1024,-0.001,1025,-0.001,1026,-0.001,1027,-0.001,1028,-0.001,1029,-0.001,1030,-0.001,1031,-0.001,1032,-0.001,1033,-0.001,1034,-0.001,1035,-0.001,1036,-0.001,1037,-0.001,1038,-0.001,1039,-0.001,1040,-0.001,1041,-0.001,1042,-0.001,1043,-0.001,1044,-0.001,1045,-0.001,1046,-0.001,1047,-0.001,1048,-0.001,1049,-0.001,1050,-0.001,1051,-0.001,1052,-0.001,1053,-0.001,1054,-0.001,1055,-0.001,1056,-0.001,1057,-0.001,1058,-0.001,1059,-0.001,1060,-0.001,1061,-0.001,1062,-0.001,1063,-0.001,1064,-0.001,1065,-0.001,1066,-0.001,1067,-0.001,1068,-0.001,1069,-0.001,1070,-0.001,1071,-0.001,1072,-0.001,1073,-0.001,1074,-0.001,1075,-0.001,1076,-0.001,1077,-0.001,1078,-0.001,1079,-0.001,1080,-0.001,1081,-0.001,1082,-0.001,1083,-0.001,1084,-0.001,1085,-0.001,1086,-0.001,1087,-0.001,1088,-0.001,1089,-0.001,1090,-0.001,1091,-0.001,1092,-0.001,1093,-0.001,1094,-0.001,1095,-0.001,1096,-0.001,1097,-0.001,1098,-0.001,1099,-0.001,1100,-0.001,1101,-0.001,1102,-0.001,1103,-0.001,1104,-0.001,1105,-0.001,1106,-0.001,1107,-0.001,1108,-0.001,1109,-0.001,1110,-0.001,1111,-0.001,1112,-0.001,1113,-0.001,1114,-0.001,1115,-0.001,1116,-0.001,1117,0,1118,0,1119,0,1120,0,1121,0,1122,0,1123,0,1124,0,1125,0,1126,0,1127,0,1128,0,1129,0,1130,0,1131,0,1132,0,1133,0,1134,0,1135,0,1136,0,1137,0,1138,0,1139,0,1140,0,1141,0,1142,0,1143,0,1144,0,1145,0,1146,0,1147,0,1148,0,1149,0,1150,0,1151,0,1152,0,1153,0,1154,0,1155,0,1156,0,1157,0,1158,0,1159,0,1160,0,1161,0,1162,0,1163,0,1164,0,1165,0,1166,0,1167,0,1168,0,1169,0,1170,0,1171,0,1172,0,1173,0,1174,0,1175,0,1176,0,1177,0,1178,0,1179,0,1180,0,1181,0,1182,0,1183,0,1184,0,1185,0,1186,0,1187,0,1188,0,1189,0,1190,0,1191,0,1192,0,1193,0,1194,0,1195,0,1196,0,1197,0,1198,0,1199,0,1200,0,1201,0,1202,0,1203,0,1204,0,1205,0,1206,0,1207,0,1208,0,1209,0,1210,0,1211,0,1212,0,1213,0,1214,0,1215,0,1216,0,1217,0,1218,0,1219,0,1220,0,1221,0,1222,0,1223,0,1224,0,1225,0,1226,0,1227,0,1228,0,1229,0,1230,0,1231,0,1232,0,1233,0,1234,0,1235,0,1236,0,1237,0,1238,0,1239,0,1240,0,1241,0,1242,0,1243,0,1244,0,1245,0,1246,0,1247,0,1248,0,1249,0,1250,0,1251,0,1252,0,1253,0,1254,0,1255,0,1256,0,1257,0,1258,0,1259,0,1260,0,1261,0,1262,0,1263,0,1264,0,1265,0,1266,0,1267,0,1268,0,1269,0,1270,0,1271,0,1272,0,1273,0,1274,0,1275,0,1276,0,1277,0,1278,0,1279,0,1280,0,1281,0,1282,0,1283,0,1284,0,1285,0,1286,0,1287,0,1288,0,1289,0,1290,0,1291,0,1292,0,1293,0,1294,0,1295,0,1296,0,1297,0,1298,0,1299,0,1300,0,1301,0,1302,0,1303,0,1304,0,1305,0,1306,0,1307,0,1308,0,1309,0,1310,0,1311,0,1312,0,1313,0,1314,0,1315,0,1316,0,1317,0,1318,0,1319,0,1320,0,1321,0,1322,0,1323,0,1324,0,1325,0,1326,0,1327,0,1328,0,1329,0,1330,0,1331,0,1332,0,1333,0,1334,0,1335,0,1336,0,1337,0,1338,0,1339,0,1340,0,1341,0,1342,0,1343,0,1344,0,1345,0,1346,0,1347,0,1348,0,1349,0,1350,0,1351,0,1352,0,1353,0,1354,0,1355,0,1356,0,1357,0,1358,0,1359,0,1360,0,1361,0,1362,0,1363,0,1364,0,1365,0,1366,0,1367,0,1368,0,1369,0,1370,0,1371,0,1372,0,1373,0,1374,0,1375,0,1376,0,1377,0,1378,0,1379,0,1380,0,1381,0,1382,0,1383,0,1384,0,1385,0,1386,0,1387,0,1388,0,1389,0,1390,0,1391,0,1392,0,1393,0,1394,0,1395,0,1396,0,1397,0,1398,0,1399,0,1400,0,1401,0,1402,0,1403,0,1404,0,1405,0,1406,0,1407,0,1408,0,1409,0,1410,0,1411,0,1412,0,1413,0,1414,0,1415,0,1416,0,1417,0,1418,0,1419,0,1420,0,1421,0,1422,0,1423,0,1424,0,1425,0,1426,0,1427,0,1428,0,1429,0,1430,0,1431,0,1432,0,1433,0,1434,0,1435,0,1436,0,1437,0,1438,0,1439,0,1440,0,1441,0,1442,0,1443,0,1444,0,1445,0,1446,0,1447,0,1448,0,1449,0,1450,0,1451,0,1452,0,1453,0,1454,0,1455,0,1456,0,1457,0,1458,0,1459,0,1460,0,1461,0,1462,0,1463,0,1464,0,1465,0,1466,0,1467,0,1468,0,1469,0,1470,0,1471,0,1472,0,1473,0,1474,0,1475,0,1476,0,1477,0,1478,0,1479,0,1480,0,1481,0,1482,0,1483,0,1484,0,1485,0,1486,0,1487,0,1488,0,1489,0,1490,0,1491,0,1492,0,1493,0,1494,0,1495,0,1496,0,1497,0,1498,0,1499,0,1500,0,1501,0,1502,0,1503,0,1504,0,1505,0,1506,0,1507,0,1508,0,1509,0,1510,0,1511,0,1512,0,1513,0,1514,0,1515,0,1516,0,1517,0,1518,0,1519,0,1520,0,1521,0,1522,0,1523,0,1524,0,1525,0,1526,0,1527,0,1528,0,1529,0,1530,0,1531,0,1532,0,1533,0,1534,0,1535,0,1536,0,1537,0,1538,0,1539,0,1540,0,1541,0,1542,0,1543,0,1544,0,1545,0,1546,0,1547,0,1548,0,1549,0,1550,0,1551,0,1552,0,1553,0,1554,0,1555,0,1556,0,1557,0,1558,0,1559,0,1560,0,1561,0,1562,0,1563,0,1564,0,1565,0,1566,0,1567,0,1568,0,1569,0,1570,0,1571,0,1572,0,1573,0,1574,0,1575,0,1576,0,1577,0,1578,0,1579,0,1580,0,1581,0,1582,0,1583,0,1584,0,1585,0,1586,0,1587,0,1588,0,1589,0,1590,0,1591,0,1592,0,1593,0,1594,0,1595,0,1596,0,1597,0,1598,0,1599,0,1600,0,1601,0,1602,0,1603,0,1604,0,1605,0,1606,0,1607,0,1608,0,1609,0,1610,0,1611,0,1612,0,1613,0,1614,0,1615,0,1616,0,1617,0,1618,0,1619,0,1620,0,1621,0,1622,0,1623,0,1624,0,1625,0,1626,0,1627,0,1628,0,1629,0,1630,0,1631,0,1632,0,1633,0,1634,0,1635,0,1636,0,1637,0,1638,0,1639,0,1640,0,1641,0,1642,0,1643,0,1644,0,1645,0,1646,0,1647,0,1648,0,1649,0,1650,0,1651,0,1652,0,1653,0,1654,0,1655,0,1656,0,1657,0,1658,0,1659,0,1660,0,1661,0,1662,0,1663,0,1664,0,1665,0,1666,0,1667,0,1668,0,1669,0,1670,0,1671,0,1672,0,1673,0,1674,0,1675,0,1676,0,1677,0,1678,0,1679,0,1680,0,1681,0,1682,0,1683,0,1684,0,1685,0,1686,0,1687,0,1688,0,1689,0,1690,0,1691,0,1692,0,1693,0,1694,0,1695,0,1696,0,1697,0,1698,0,1699,0,1700,0,1701,0,1702,0,1703,0,1704,0,1705,0,1706,0,1707,0,1708,0,1709,0,1710,0,1711,0,1712,0,1713,0,1714,0,1715,0,1716,0,1717,0,1718,0,1719,0,1720,0,1721,0,1722,0,1723,0,1724,0,1725,0,1726,0,1727,0,1728,0,1729,0,1730,0,1731,0,1732,0,1733,0,1734,0,1735,0,1736,0,1737,0,1738,0,1739,0,1740,0,1741,0,1742,0,1743,0,1744,0,1745,0,1746,0,1747,0,1748,0,1749,0,1750,0,1751,0,1752,0,1753,0,1754,0,1755,0,1756,0,1757,0,1758,0,1759,0,1760,0,1761,0,1762,0,1763,0,1764,0,1765,0,1766,0,1767,0,1768,0,1769,0,1770,0,1771,0,1772,0,1773,0,1774,0,1775,0,1776,0,1777,0,1778,0,1779,0,1780,0,1781,0,1782,0,1783,0,1784,0,1785,0,1786,0,1787,0,1788,0,1789,0,1790,0,1791,0,1792,0,1793,0,1794,0,1795,0,1796,0,1797,0,1798,0,1799,0,1800,0,1801,0,1802,0,1803,0,1804,0,1805,0,1806,0,1807,0,1808,0,1809,0,1810,0,1811,0,1812,0,1813,0,1814,0,1815,0,1816,0,1817,0,1818,0,1819,0,1820,0,1821,0,1822,0,1823,0,1824,0,1825,0,1826,0,1827,0,1828,0,1829,0,1830,0,1831,0,1832,0,1833,0,1834,0,1835,0,1836,0,1837,0,1838,0,1839,0,1840,0,1841,0,1842,0,1843,0,1844,0,1845,0,1846,0,1847,0,1848,0,1849,0,1850,0,1851,0,1852,0,1853,0,1854,0,1855,0,1856,0,1857,0,1858,0,1859,0,1860,0,1861,0,1862,0,1863,0,1864,0,1865,0,1866,0,1867,0,1868,0,1869,0,1870,0,1871,0,1872,0,1873,0,1874,0,1875,0,1876,0,1877,0,1878,0,1879,0,1880,0,1881,0,1882,0,1883,0,1884,0,1885,0,1886,0,1887,0,1888,0,1889,0,1890,0,1891,0,1892,0,1893,0,1894,0,1895,0,1896,0,1897,0,1898,0,1899,0,1900,0,1901,0,1902,0,1903,0,1904,0,1905,0,1906,0,1907,0,1908,0,1909,0,1910,0,1911,0,1912,0,1913,0,1914,0,1915,0,1916,0,1917,0,1918,0,1919,0,1920,0,1921,0,1922,0,1923,0,1924,0,1925,0,1926,0,1927,0,1928,0,1929,0,1930,0,1931,0,1932,0,1933,0,1934,0,1935,0,1936,0,1937,0,1938,0,1939,0,1940,0,1941,0,1942,0,1943,0,1944,0,1945,0,1946,0,1947,0,1948,0,1949,0,1950,0,1951,0,1952,0,1953,0,1954,0,1955,0,1956,0,1957,0,1958,0,1959,0,1960,0,1961,0,1962,0,1963,0,1964,0,1965,0,1966,0,1967,0,1968,0,1969,0,1970,0,1971,0,1972,0,1973,0,1974,0,1975,0,1976,0,1977,0,1978,0,1979,0,1980,0,1981,0,1982,0,1983,0,1984,0,1985,0,1986,0,1987,0,1988,0,1989,0,1990,0,1991,0,1992,0,1993,0,1994,0,1995,0,1996,0,1997,0,1998,0,1999,0,2000,0,2001,0,2002,0,2003,0,2004,0,2005,0,2006,0,2007,0,2008,0,2009,0,2010,0,2011,0,2012,0,2013,0,2014,0,2015,0,2016,0,2017,0,2018,0,2019,0,2020,0,2021,0,2022,0,2023,0,2024,0,2025,0,2026,0,2027,0,2028,0,2029,0,2030,0,2031,0,2032,0,2033,0,2034,0,2035,0,2036,0,2037,0,2038,0,2039,0,2040,0,2041,0,2042,0,2043,0,2044,0,2045,0,2046,0,2047,0,2048,0,2049,0,2050,0,2051,0,2052,0,2053,0,2054,0,2055,0,2056,0,2057,0,2058,0,2059,0,2060,0,2061,0,2062,0,2063,0,2064,0,2065,0,2066,0,2067,0,2068,0,2069,0,2070,0,2071,0,2072,0,2073,0,2074,0,2075,0,2076,0,2077,0,2078,0,2079,0,2080,0,2081,0,2082,0,2083,0,2084,0,2085,0,2086,0,2087,0,2088,0,2089,0,2090,0,2091,0,2092,0,2093,0,2094,0,2095,0,2096,0,2097,0,2098,0,2099,0,2100,0,2101,0,2102,0,2103,0,2104,0,2105,0,2106,0,2107,0,2108,0,2109,0,2110,0,2111,0,2112,0,2113,0,2114,0,2115,0,2116,0,2117,0,2118,0,2119,0,2120,0,2121,0,2122,0,2123,0,2124,0,2125,0,2126,0,2127,0,2128,0,2129,0,2130,0,2131,0,2132,0,2133,0,2134,0,2135,0,2136,0,2137,0,2138,0,2139,0,2140,0,2141,0,2142,0,2143,0,2144,0,2145,0,2146,0,2147,0,2148,0,2149,0,2150,0,2151,0,2152,0,2153,0,2154,0,2155,0,2156,0,2157,0,2158,0,2159,0,2160,0,2161,0,2162,0,2163,0,2164,0,2165,0,2166,0,2167,0,2168,0,2169,0,2170,0,2171,0,2172,0,2173,0,2174,0,2175,0,2176,0,2177,0,2178,0,2179,0,2180,0,2181,0,2182,0,2183,0,2184,0,2185,0,2186,0,2187,0,2188,0,2189,0,2190,0,2191,0,2192,0,2193,0,2194,0,2195,0,2196,0,2197,0,2198,0,2199,0,2200,0,2201,0,2202,0,2203,0,2204,0,2205,0,2206,0,2207,0,2208,0,2209,0,2210,0,2211,0,2212,0,2213,0,2214,0,2215,0,2216,0,2217,0,2218,0,2219,0,2220,0,2221,0,2222,0,2223,0,2224,0,2225,0,2226,0,2227,0,2228,0,2229,0,2230,0,2231,0,2232,0,2233,0,2234,0,2235,0,2236,0,2237,0,2238,0,2239,0,2240,0,2241,0,2242,0,2243,0,2244,0,2245,0,2246,0,2247,0,2248,0,2249,0,2250,0,2251,0,2252,0,2253,0,2254,0,2255,0,2256,0,2257,0,2258,0,2259,0,2260,0,2261,0,2262,0,2263,0,2264,0,2265,0,2266,0,2267,0,2268,0,2269,0,2270,0,2271,0,2272,0,2273,0,2274,0,2275,0,2276,0,2277,0,2278,0,2279,0,2280,0,2281,0,2282,0,2283,0,2284,0,2285,0,2286,0,2287,0,2288,0,2289,0,2290,0,2291,0,2292,0,2293,0,2294,0,2295,0,2296,0,2297,0,2298,0,2299,0,2300,0,2301,0,2302,0,2303,0,2304,0,2305,0,2306,0,2307,0,2308,0,2309,0,2310,0,2311,0,2312,0,2313,0,2314,0,2315,0,2316,0,2317,0,2318,0,2319,0,2320,0,2321,0,2322,0,2323,0,2324,0,2325,0,2326,0,2327,0,2328,0,2329,0,2330,0,2331,0,2332,0,2333,0,2334,0,2335,0,2336,0,2337,0,2338,0,2339,0,2340,0,2341,0,2342,0,2343,0,2344,0,2345,0,2346,0,2347,0,2348,0,2349,0,2350,0,2351,0,2352,0,2353,0,2354,0,2355,0,2356,0,2357,0,2358,0,2359,0,2360,0,2361,0,2362,0,2363,0,2364,0,2365,0,2366,0,2367,0,2368,0,2369,0,2370,0,2371,0,2372,0,2373,0,2374,0,2375,0,2376,0,2377,0,2378,0,2379,0,2380,0,2381,0,2382,0,2383,0,2384,0,2385,0,2386,0,2387,0,2388,0,2389,0,2390,0,2391,0,2392,0,2393,0,2394,0,2395,0,2396,0,2397,0,2398,0,2399,0,2400,0,2401,0,2402,0,2403,0,2404,0,2405,0,2406,0,2407,0,2408,0,2409,0,2410,0,2411,0,2412,0,2413,0,2414,0,2415,0,2416,0,2417,0,2418,0,2419,0,2420,0,2421,0,2422,0,2423,0,2424,0,2425,0,2426,0,2427,0,2428,0,2429,0,2430,0,2431,0,2432,0,2433,0,2434,0,2435,0,2436,0,2437,0,2438,0,2439,0,2440,0,2441,0,2442,0,2443,0,2444,0,2445,0,2446,0,2447,0,2448,0,2449,0,2450,0,2451,0,2452,0,2453,0,2454,0,2455,0,2456,0,2457,0,2458,0,2459,0,2460,0,2461,0,2462,0,2463,0,2464,0,2465,0,2466,0,2467,0,2468,0,2469,0,2470,0,2471,0,2472,0,2473,0,2474,0,2475,0,2476,0,2477,0,2478,0,2479,0,2480,0,2481,0,2482,0,2483,0,2484,0,2485,0,2486,0,2487,0,2488,0,2489,0,2490,0,2491,0,2492,0,2493,0,2494,0,2495,0,2496,0,2497,0,2498,0,2499,0,2500,0,2501,0,2502,0,2503,0,2504,0,2505,0,2506,0,2507,0,2508,0,2509,0,2510,0,2511,0,2512,0,2513,0,2514,0,2515,0,2516,0,2517,0,2518,0,2519,0,2520,0,2521,0,2522,0,2523,0,2524,0,2525,0,2526,0,2527,0,2528,0,2529,0,2530,0,2531,0,2532,0,2533,0,2534,0,2535,0,2536,0,2537,0,2538,0,2539,0,2540,0,2541,0,2542,0,2543,0,2544,0,2545,0,2546,0,2547,0,2548,0,2549,0,2550,0,2551,0,2552,0,2553,0,2554,0,2555,0,2556,0,2557,0,2558,0,2559,0,2560,0,2561,0,2562,0,2563,0,2564,0,2565,0,2566,0,2567,0,2568,0,2569,0,2570,0,2571,0,2572,0,2573,0,2574,0,2575,0,2576,0,2577,0,2578,0,2579,0,2580,0,2581,0,2582,0,2583,0,2584,0,2585,0,2586,0,2587,0,2588,0,2589,0,2590,0,2591,0,2592,0,2593,0,2594,0,2595,0,2596,0,2597,0,2598,0,2599,0,2600,0,2601,0,2602,0,2603,0,2604,0)
.param ASET=table(run,1,7.07107,2,7.07107,3,7.07107,4,10,5,10,6,10,7,14.1421,8,14.1421,9,14.1421,10,22.3607,11,22.3607,12,22.3607,13,7.07107,14,7.07107,15,7.07107,16,10,17,10,18,10,19,14.1421,20,14.1421,21,14.1421,22,22.3607,23,22.3607,24,22.3607,25,7.07107,26,7.07107,27,7.07107,28,10,29,10,30,10,31,14.1421,32,14.1421,33,14.1421,34,22.3607,35,22.3607,36,22.3607,37,7.07107,38,7.07107,39,7.07107,40,10,41,10,42,10,43,14.1421,44,14.1421,45,14.1421,46,22.3607,47,22.3607,48,22.3607,49,7.07107,50,7.07107,51,7.07107,52,10,53,10,54,10,55,14.1421,56,14.1421,57,14.1421,58,22.3607,59,22.3607,60,22.3607,61,7.07107,62,7.07107,63,7.07107,64,10,65,10,66,10,67,14.1421,68,14.1421,69,14.1421,70,22.3607,71,22.3607,72,22.3607,73,7.07107,74,7.07107,75,7.07107,76,10,77,10,78,10,79,14.1421,80,14.1421,81,14.1421,82,22.3607,83,22.3607,84,22.3607,85,7.07107,86,7.07107,87,7.07107,88,10,89,10,90,10,91,14.1421,92,14.1421,93,14.1421,94,22.3607,95,22.3607,96,22.3607,97,7.07107,98,7.07107,99,7.07107,100,10,101,10,102,10,103,14.1421,104,14.1421,105,14.1421,106,22.3607,107,22.3607,108,22.3607,109,7.07107,110,7.07107,111,7.07107,112,10,113,10,114,10,115,14.1421,116,14.1421,117,14.1421,118,22.3607,119,22.3607,120,22.3607,121,7.07107,122,7.07107,123,7.07107,124,10,125,10,126,10,127,14.1421,128,14.1421,129,14.1421,130,22.3607,131,22.3607,132,22.3607,133,7.07107,134,7.07107,135,7.07107,136,10,137,10,138,10,139,14.1421,140,14.1421,141,14.1421,142,22.3607,143,22.3607,144,22.3607,145,7.07107,146,7.07107,147,7.07107,148,10,149,10,150,10,151,14.1421,152,14.1421,153,14.1421,154,22.3607,155,22.3607,156,22.3607,157,7.07107,158,7.07107,159,7.07107,160,10,161,10,162,10,163,14.1421,164,14.1421,165,14.1421,166,22.3607,167,22.3607,168,22.3607,169,7.07107,170,7.07107,171,7.07107,172,10,173,10,174,10,175,14.1421,176,14.1421,177,14.1421,178,22.3607,179,22.3607,180,22.3607,181,7.07107,182,7.07107,183,7.07107,184,10,185,10,186,10,187,14.1421,188,14.1421,189,14.1421,190,22.3607,191,22.3607,192,22.3607,193,7.07107,194,7.07107,195,7.07107,196,10,197,10,198,10,199,14.1421,200,14.1421,201,14.1421,202,22.3607,203,22.3607,204,22.3607,205,7.07107,206,7.07107,207,7.07107,208,10,209,10,210,10,211,14.1421,212,14.1421,213,14.1421,214,22.3607,215,22.3607,216,22.3607,217,7.07107,218,7.07107,219,7.07107,220,10,221,10,222,10,223,14.1421,224,14.1421,225,14.1421,226,22.3607,227,22.3607,228,22.3607,229,7.07107,230,7.07107,231,7.07107,232,10,233,10,234,10,235,14.1421,236,14.1421,237,14.1421,238,22.3607,239,22.3607,240,22.3607,241,7.07107,242,7.07107,243,7.07107,244,10,245,10,246,10,247,14.1421,248,14.1421,249,14.1421,250,22.3607,251,22.3607,252,22.3607,253,7.07107,254,7.07107,255,7.07107,256,10,257,10,258,10,259,14.1421,260,14.1421,261,14.1421,262,22.3607,263,22.3607,264,22.3607,265,7.07107,266,7.07107,267,7.07107,268,10,269,10,270,10,271,14.1421,272,14.1421,273,14.1421,274,22.3607,275,22.3607,276,22.3607,277,7.07107,278,7.07107,279,7.07107,280,10,281,10,282,10,283,14.1421,284,14.1421,285,14.1421,286,22.3607,287,22.3607,288,22.3607,289,7.07107,290,7.07107,291,7.07107,292,10,293,10,294,10,295,14.1421,296,14.1421,297,14.1421,298,22.3607,299,22.3607,300,22.3607,301,7.07107,302,7.07107,303,7.07107,304,10,305,10,306,10,307,14.1421,308,14.1421,309,14.1421,310,22.3607,311,22.3607,312,22.3607,313,7.07107,314,7.07107,315,7.07107,316,10,317,10,318,10,319,14.1421,320,14.1421,321,14.1421,322,22.3607,323,22.3607,324,22.3607,325,7.07107,326,7.07107,327,7.07107,328,10,329,10,330,10,331,14.1421,332,14.1421,333,14.1421,334,22.3607,335,22.3607,336,22.3607,337,7.07107,338,7.07107,339,7.07107,340,10,341,10,342,10,343,14.1421,344,14.1421,345,14.1421,346,22.3607,347,22.3607,348,22.3607,349,7.07107,350,7.07107,351,7.07107,352,10,353,10,354,10,355,14.1421,356,14.1421,357,14.1421,358,22.3607,359,22.3607,360,22.3607,361,7.07107,362,7.07107,363,7.07107,364,10,365,10,366,10,367,14.1421,368,14.1421,369,14.1421,370,22.3607,371,22.3607,372,22.3607,373,7.07107,374,7.07107,375,7.07107,376,10,377,10,378,10,379,14.1421,380,14.1421,381,14.1421,382,22.3607,383,22.3607,384,22.3607,385,7.07107,386,7.07107,387,7.07107,388,10,389,10,390,10,391,14.1421,392,14.1421,393,14.1421,394,22.3607,395,22.3607,396,22.3607,397,7.07107,398,7.07107,399,7.07107,400,10,401,10,402,10,403,14.1421,404,14.1421,405,14.1421,406,22.3607,407,22.3607,408,22.3607,409,7.07107,410,7.07107,411,7.07107,412,10,413,10,414,10,415,14.1421,416,14.1421,417,14.1421,418,22.3607,419,22.3607,420,22.3607,421,7.07107,422,7.07107,423,7.07107,424,10,425,10,426,10,427,14.1421,428,14.1421,429,14.1421,430,22.3607,431,22.3607,432,22.3607,433,7.07107,434,7.07107,435,7.07107,436,10,437,10,438,10,439,14.1421,440,14.1421,441,14.1421,442,22.3607,443,22.3607,444,22.3607,445,7.07107,446,7.07107,447,7.07107,448,10,449,10,450,10,451,14.1421,452,14.1421,453,14.1421,454,22.3607,455,22.3607,456,22.3607,457,7.07107,458,7.07107,459,7.07107,460,10,461,10,462,10,463,14.1421,464,14.1421,465,14.1421,466,22.3607,467,22.3607,468,22.3607,469,7.07107,470,7.07107,471,7.07107,472,10,473,10,474,10,475,14.1421,476,14.1421,477,14.1421,478,22.3607,479,22.3607,480,22.3607,481,7.07107,482,7.07107,483,7.07107,484,10,485,10,486,10,487,14.1421,488,14.1421,489,14.1421,490,22.3607,491,22.3607,492,22.3607,493,7.07107,494,7.07107,495,7.07107,496,10,497,10,498,10,499,14.1421,500,14.1421,501,14.1421,502,22.3607,503,22.3607,504,22.3607,505,7.07107,506,7.07107,507,7.07107,508,10,509,10,510,10,511,14.1421,512,14.1421,513,14.1421,514,22.3607,515,22.3607,516,22.3607,517,7.07107,518,7.07107,519,7.07107,520,10,521,10,522,10,523,14.1421,524,14.1421,525,14.1421,526,22.3607,527,22.3607,528,22.3607,529,7.07107,530,7.07107,531,7.07107,532,10,533,10,534,10,535,14.1421,536,14.1421,537,14.1421,538,22.3607,539,22.3607,540,22.3607,541,7.07107,542,7.07107,543,7.07107,544,10,545,10,546,10,547,14.1421,548,14.1421,549,14.1421,550,22.3607,551,22.3607,552,22.3607,553,7.07107,554,7.07107,555,7.07107,556,10,557,10,558,10,559,14.1421,560,14.1421,561,14.1421,562,22.3607,563,22.3607,564,22.3607,565,7.07107,566,7.07107,567,7.07107,568,10,569,10,570,10,571,14.1421,572,14.1421,573,14.1421,574,22.3607,575,22.3607,576,22.3607,577,7.07107,578,7.07107,579,7.07107,580,10,581,10,582,10,583,14.1421,584,14.1421,585,14.1421,586,22.3607,587,22.3607,588,22.3607,589,7.07107,590,7.07107,591,7.07107,592,10,593,10,594,10,595,14.1421,596,14.1421,597,14.1421,598,22.3607,599,22.3607,600,22.3607,601,7.07107,602,7.07107,603,7.07107,604,10,605,10,606,10,607,14.1421,608,14.1421,609,14.1421,610,22.3607,611,22.3607,612,22.3607,613,7.07107,614,7.07107,615,7.07107,616,10,617,10,618,10,619,14.1421,620,14.1421,621,14.1421,622,22.3607,623,22.3607,624,22.3607,625,7.07107,626,7.07107,627,7.07107,628,10,629,10,630,10,631,14.1421,632,14.1421,633,14.1421,634,22.3607,635,22.3607,636,22.3607,637,7.07107,638,7.07107,639,7.07107,640,10,641,10,642,10,643,14.1421,644,14.1421,645,14.1421,646,22.3607,647,22.3607,648,22.3607,649,7.07107,650,7.07107,651,7.07107,652,10,653,10,654,10,655,14.1421,656,14.1421,657,14.1421,658,22.3607,659,22.3607,660,22.3607,661,7.07107,662,7.07107,663,7.07107,664,10,665,10,666,10,667,14.1421,668,14.1421,669,14.1421,670,22.3607,671,22.3607,672,22.3607,673,7.07107,674,7.07107,675,7.07107,676,10,677,10,678,10,679,14.1421,680,14.1421,681,14.1421,682,22.3607,683,22.3607,684,22.3607,685,7.07107,686,7.07107,687,7.07107,688,10,689,10,690,10,691,14.1421,692,14.1421,693,14.1421,694,22.3607,695,22.3607,696,22.3607,697,7.07107,698,7.07107,699,7.07107,700,10,701,10,702,10,703,14.1421,704,14.1421,705,14.1421,706,22.3607,707,22.3607,708,22.3607,709,7.07107,710,7.07107,711,7.07107,712,10,713,10,714,10,715,14.1421,716,14.1421,717,14.1421,718,22.3607,719,22.3607,720,22.3607,721,7.07107,722,7.07107,723,7.07107,724,10,725,10,726,10,727,14.1421,728,14.1421,729,14.1421,730,22.3607,731,22.3607,732,22.3607,733,7.07107,734,7.07107,735,7.07107,736,10,737,10,738,10,739,14.1421,740,14.1421,741,14.1421,742,22.3607,743,22.3607,744,22.3607,745,7.07107,746,7.07107,747,7.07107,748,10,749,10,750,10,751,14.1421,752,14.1421,753,14.1421,754,22.3607,755,22.3607,756,22.3607,757,7.07107,758,7.07107,759,7.07107,760,10,761,10,762,10,763,14.1421,764,14.1421,765,14.1421,766,22.3607,767,22.3607,768,22.3607,769,7.07107,770,7.07107,771,7.07107,772,10,773,10,774,10,775,14.1421,776,14.1421,777,14.1421,778,22.3607,779,22.3607,780,22.3607,781,7.07107,782,7.07107,783,7.07107,784,10,785,10,786,10,787,14.1421,788,14.1421,789,14.1421,790,22.3607,791,22.3607,792,22.3607,793,7.07107,794,7.07107,795,7.07107,796,10,797,10,798,10,799,14.1421,800,14.1421,801,14.1421,802,22.3607,803,22.3607,804,22.3607,805,7.07107,806,7.07107,807,7.07107,808,10,809,10,810,10,811,14.1421,812,14.1421,813,14.1421,814,22.3607,815,22.3607,816,22.3607,817,7.07107,818,7.07107,819,7.07107,820,10,821,10,822,10,823,14.1421,824,14.1421,825,14.1421,826,22.3607,827,22.3607,828,22.3607,829,7.07107,830,7.07107,831,7.07107,832,10,833,10,834,10,835,14.1421,836,14.1421,837,14.1421,838,22.3607,839,22.3607,840,22.3607,841,7.07107,842,7.07107,843,7.07107,844,10,845,10,846,10,847,14.1421,848,14.1421,849,14.1421,850,22.3607,851,22.3607,852,22.3607,853,7.07107,854,7.07107,855,7.07107,856,10,857,10,858,10,859,14.1421,860,14.1421,861,14.1421,862,22.3607,863,22.3607,864,22.3607,865,7.07107,866,7.07107,867,7.07107,868,10,869,10,870,10,871,14.1421,872,14.1421,873,14.1421,874,22.3607,875,22.3607,876,22.3607,877,7.07107,878,7.07107,879,7.07107,880,10,881,10,882,10,883,14.1421,884,14.1421,885,14.1421,886,22.3607,887,22.3607,888,22.3607,889,7.07107,890,7.07107,891,7.07107,892,10,893,10,894,10,895,14.1421,896,14.1421,897,14.1421,898,22.3607,899,22.3607,900,22.3607,901,7.07107,902,7.07107,903,7.07107,904,10,905,10,906,10,907,14.1421,908,14.1421,909,14.1421,910,22.3607,911,22.3607,912,22.3607,913,7.07107,914,7.07107,915,7.07107,916,10,917,10,918,10,919,14.1421,920,14.1421,921,14.1421,922,22.3607,923,22.3607,924,22.3607,925,7.07107,926,7.07107,927,7.07107,928,10,929,10,930,10,931,14.1421,932,14.1421,933,14.1421,934,22.3607,935,22.3607,936,22.3607,937,7.07107,938,7.07107,939,7.07107,940,10,941,10,942,10,943,14.1421,944,14.1421,945,14.1421,946,22.3607,947,22.3607,948,22.3607,949,7.07107,950,7.07107,951,7.07107,952,10,953,10,954,10,955,14.1421,956,14.1421,957,14.1421,958,22.3607,959,22.3607,960,22.3607,961,7.07107,962,7.07107,963,7.07107,964,10,965,10,966,10,967,14.1421,968,14.1421,969,14.1421,970,22.3607,971,22.3607,972,22.3607,973,7.07107,974,7.07107,975,7.07107,976,10,977,10,978,10,979,14.1421,980,14.1421,981,14.1421,982,22.3607,983,22.3607,984,22.3607,985,7.07107,986,7.07107,987,7.07107,988,10,989,10,990,10,991,14.1421,992,14.1421,993,14.1421,994,22.3607,995,22.3607,996,22.3607,997,7.07107,998,7.07107,999,7.07107,1000,10,1001,10,1002,10,1003,14.1421,1004,14.1421,1005,14.1421,1006,22.3607,1007,22.3607,1008,22.3607,1009,7.07107,1010,7.07107,1011,7.07107,1012,10,1013,10,1014,10,1015,14.1421,1016,14.1421,1017,14.1421,1018,22.3607,1019,22.3607,1020,22.3607,1021,7.07107,1022,7.07107,1023,7.07107,1024,10,1025,10,1026,10,1027,14.1421,1028,14.1421,1029,14.1421,1030,22.3607,1031,22.3607,1032,22.3607,1033,7.07107,1034,7.07107,1035,7.07107,1036,10,1037,10,1038,10,1039,14.1421,1040,14.1421,1041,14.1421,1042,22.3607,1043,22.3607,1044,22.3607,1045,7.07107,1046,7.07107,1047,7.07107,1048,10,1049,10,1050,10,1051,14.1421,1052,14.1421,1053,14.1421,1054,22.3607,1055,22.3607,1056,22.3607,1057,7.07107,1058,7.07107,1059,7.07107,1060,10,1061,10,1062,10,1063,14.1421,1064,14.1421,1065,14.1421,1066,22.3607,1067,22.3607,1068,22.3607,1069,7.07107,1070,7.07107,1071,7.07107,1072,10,1073,10,1074,10,1075,14.1421,1076,14.1421,1077,14.1421,1078,22.3607,1079,22.3607,1080,22.3607,1081,7.07107,1082,7.07107,1083,7.07107,1084,10,1085,10,1086,10,1087,14.1421,1088,14.1421,1089,14.1421,1090,22.3607,1091,22.3607,1092,22.3607,1093,7.07107,1094,7.07107,1095,7.07107,1096,10,1097,10,1098,10,1099,14.1421,1100,14.1421,1101,14.1421,1102,22.3607,1103,22.3607,1104,22.3607,1105,7.07107,1106,7.07107,1107,7.07107,1108,10,1109,10,1110,10,1111,14.1421,1112,14.1421,1113,14.1421,1114,22.3607,1115,22.3607,1116,22.3607,1117,7.07107,1118,7.07107,1119,7.07107,1120,10,1121,10,1122,10,1123,14.1421,1124,14.1421,1125,14.1421,1126,20,1127,20,1128,20,1129,7.07107,1130,7.07107,1131,7.07107,1132,10,1133,10,1134,10,1135,14.1421,1136,14.1421,1137,14.1421,1138,20,1139,20,1140,20,1141,7.07107,1142,7.07107,1143,7.07107,1144,10,1145,10,1146,10,1147,14.1421,1148,14.1421,1149,14.1421,1150,20,1151,20,1152,20,1153,7.07107,1154,7.07107,1155,7.07107,1156,10,1157,10,1158,10,1159,14.1421,1160,14.1421,1161,14.1421,1162,20,1163,20,1164,20,1165,7.07107,1166,7.07107,1167,7.07107,1168,10,1169,10,1170,10,1171,14.1421,1172,14.1421,1173,14.1421,1174,20,1175,20,1176,20,1177,7.07107,1178,7.07107,1179,7.07107,1180,10,1181,10,1182,10,1183,14.1421,1184,14.1421,1185,14.1421,1186,20,1187,20,1188,20,1189,7.07107,1190,7.07107,1191,7.07107,1192,10,1193,10,1194,10,1195,14.1421,1196,14.1421,1197,14.1421,1198,20,1199,20,1200,20,1201,7.07107,1202,7.07107,1203,7.07107,1204,10,1205,10,1206,10,1207,14.1421,1208,14.1421,1209,14.1421,1210,20,1211,20,1212,20,1213,7.07107,1214,7.07107,1215,7.07107,1216,10,1217,10,1218,10,1219,14.1421,1220,14.1421,1221,14.1421,1222,20,1223,20,1224,20,1225,7.07107,1226,7.07107,1227,7.07107,1228,10,1229,10,1230,10,1231,14.1421,1232,14.1421,1233,14.1421,1234,20,1235,20,1236,20,1237,7.07107,1238,7.07107,1239,7.07107,1240,10,1241,10,1242,10,1243,14.1421,1244,14.1421,1245,14.1421,1246,20,1247,20,1248,20,1249,7.07107,1250,7.07107,1251,7.07107,1252,10,1253,10,1254,10,1255,14.1421,1256,14.1421,1257,14.1421,1258,20,1259,20,1260,20,1261,7.07107,1262,7.07107,1263,7.07107,1264,10,1265,10,1266,10,1267,14.1421,1268,14.1421,1269,14.1421,1270,20,1271,20,1272,20,1273,7.07107,1274,7.07107,1275,7.07107,1276,10,1277,10,1278,10,1279,14.1421,1280,14.1421,1281,14.1421,1282,20,1283,20,1284,20,1285,7.07107,1286,7.07107,1287,7.07107,1288,10,1289,10,1290,10,1291,14.1421,1292,14.1421,1293,14.1421,1294,20,1295,20,1296,20,1297,7.07107,1298,7.07107,1299,7.07107,1300,10,1301,10,1302,10,1303,14.1421,1304,14.1421,1305,14.1421,1306,20,1307,20,1308,20,1309,7.07107,1310,7.07107,1311,7.07107,1312,10,1313,10,1314,10,1315,14.1421,1316,14.1421,1317,14.1421,1318,20,1319,20,1320,20,1321,7.07107,1322,7.07107,1323,7.07107,1324,10,1325,10,1326,10,1327,14.1421,1328,14.1421,1329,14.1421,1330,20,1331,20,1332,20,1333,7.07107,1334,7.07107,1335,7.07107,1336,10,1337,10,1338,10,1339,14.1421,1340,14.1421,1341,14.1421,1342,20,1343,20,1344,20,1345,7.07107,1346,7.07107,1347,7.07107,1348,10,1349,10,1350,10,1351,14.1421,1352,14.1421,1353,14.1421,1354,20,1355,20,1356,20,1357,7.07107,1358,7.07107,1359,7.07107,1360,10,1361,10,1362,10,1363,14.1421,1364,14.1421,1365,14.1421,1366,20,1367,20,1368,20,1369,7.07107,1370,7.07107,1371,7.07107,1372,10,1373,10,1374,10,1375,14.1421,1376,14.1421,1377,14.1421,1378,20,1379,20,1380,20,1381,7.07107,1382,7.07107,1383,7.07107,1384,10,1385,10,1386,10,1387,14.1421,1388,14.1421,1389,14.1421,1390,20,1391,20,1392,20,1393,7.07107,1394,7.07107,1395,7.07107,1396,10,1397,10,1398,10,1399,14.1421,1400,14.1421,1401,14.1421,1402,20,1403,20,1404,20,1405,7.07107,1406,7.07107,1407,7.07107,1408,10,1409,10,1410,10,1411,14.1421,1412,14.1421,1413,14.1421,1414,20,1415,20,1416,20,1417,7.07107,1418,7.07107,1419,7.07107,1420,10,1421,10,1422,10,1423,14.1421,1424,14.1421,1425,14.1421,1426,20,1427,20,1428,20,1429,7.07107,1430,7.07107,1431,7.07107,1432,10,1433,10,1434,10,1435,14.1421,1436,14.1421,1437,14.1421,1438,20,1439,20,1440,20,1441,7.07107,1442,7.07107,1443,7.07107,1444,10,1445,10,1446,10,1447,14.1421,1448,14.1421,1449,14.1421,1450,20,1451,20,1452,20,1453,7.07107,1454,7.07107,1455,7.07107,1456,10,1457,10,1458,10,1459,14.1421,1460,14.1421,1461,14.1421,1462,20,1463,20,1464,20,1465,7.07107,1466,7.07107,1467,7.07107,1468,10,1469,10,1470,10,1471,14.1421,1472,14.1421,1473,14.1421,1474,20,1475,20,1476,20,1477,7.07107,1478,7.07107,1479,7.07107,1480,10,1481,10,1482,10,1483,14.1421,1484,14.1421,1485,14.1421,1486,20,1487,20,1488,20,1489,7.07107,1490,7.07107,1491,7.07107,1492,10,1493,10,1494,10,1495,14.1421,1496,14.1421,1497,14.1421,1498,22.3607,1499,22.3607,1500,22.3607,1501,7.07107,1502,7.07107,1503,7.07107,1504,10,1505,10,1506,10,1507,14.1421,1508,14.1421,1509,14.1421,1510,22.3607,1511,22.3607,1512,22.3607,1513,7.07107,1514,7.07107,1515,7.07107,1516,10,1517,10,1518,10,1519,14.1421,1520,14.1421,1521,14.1421,1522,22.3607,1523,22.3607,1524,22.3607,1525,7.07107,1526,7.07107,1527,7.07107,1528,10,1529,10,1530,10,1531,14.1421,1532,14.1421,1533,14.1421,1534,22.3607,1535,22.3607,1536,22.3607,1537,7.07107,1538,7.07107,1539,7.07107,1540,10,1541,10,1542,10,1543,14.1421,1544,14.1421,1545,14.1421,1546,22.3607,1547,22.3607,1548,22.3607,1549,7.07107,1550,7.07107,1551,7.07107,1552,10,1553,10,1554,10,1555,14.1421,1556,14.1421,1557,14.1421,1558,22.3607,1559,22.3607,1560,22.3607,1561,7.07107,1562,7.07107,1563,7.07107,1564,10,1565,10,1566,10,1567,14.1421,1568,14.1421,1569,14.1421,1570,22.3607,1571,22.3607,1572,22.3607,1573,7.07107,1574,7.07107,1575,7.07107,1576,10,1577,10,1578,10,1579,14.1421,1580,14.1421,1581,14.1421,1582,22.3607,1583,22.3607,1584,22.3607,1585,7.07107,1586,7.07107,1587,7.07107,1588,10,1589,10,1590,10,1591,14.1421,1592,14.1421,1593,14.1421,1594,22.3607,1595,22.3607,1596,22.3607,1597,7.07107,1598,7.07107,1599,7.07107,1600,10,1601,10,1602,10,1603,14.1421,1604,14.1421,1605,14.1421,1606,22.3607,1607,22.3607,1608,22.3607,1609,7.07107,1610,7.07107,1611,7.07107,1612,10,1613,10,1614,10,1615,14.1421,1616,14.1421,1617,14.1421,1618,22.3607,1619,22.3607,1620,22.3607,1621,7.07107,1622,7.07107,1623,7.07107,1624,10,1625,10,1626,10,1627,14.1421,1628,14.1421,1629,14.1421,1630,22.3607,1631,22.3607,1632,22.3607,1633,7.07107,1634,7.07107,1635,7.07107,1636,10,1637,10,1638,10,1639,14.1421,1640,14.1421,1641,14.1421,1642,22.3607,1643,22.3607,1644,22.3607,1645,7.07107,1646,7.07107,1647,7.07107,1648,10,1649,10,1650,10,1651,14.1421,1652,14.1421,1653,14.1421,1654,22.3607,1655,22.3607,1656,22.3607,1657,7.07107,1658,7.07107,1659,7.07107,1660,10,1661,10,1662,10,1663,14.1421,1664,14.1421,1665,14.1421,1666,22.3607,1667,22.3607,1668,22.3607,1669,7.07107,1670,7.07107,1671,7.07107,1672,10,1673,10,1674,10,1675,14.1421,1676,14.1421,1677,14.1421,1678,22.3607,1679,22.3607,1680,22.3607,1681,7.07107,1682,7.07107,1683,7.07107,1684,10,1685,10,1686,10,1687,14.1421,1688,14.1421,1689,14.1421,1690,22.3607,1691,22.3607,1692,22.3607,1693,7.07107,1694,7.07107,1695,7.07107,1696,10,1697,10,1698,10,1699,14.1421,1700,14.1421,1701,14.1421,1702,22.3607,1703,22.3607,1704,22.3607,1705,7.07107,1706,7.07107,1707,7.07107,1708,10,1709,10,1710,10,1711,14.1421,1712,14.1421,1713,14.1421,1714,22.3607,1715,22.3607,1716,22.3607,1717,7.07107,1718,7.07107,1719,7.07107,1720,10,1721,10,1722,10,1723,14.1421,1724,14.1421,1725,14.1421,1726,22.3607,1727,22.3607,1728,22.3607,1729,7.07107,1730,7.07107,1731,7.07107,1732,10,1733,10,1734,10,1735,14.1421,1736,14.1421,1737,14.1421,1738,22.3607,1739,22.3607,1740,22.3607,1741,7.07107,1742,7.07107,1743,7.07107,1744,10,1745,10,1746,10,1747,14.1421,1748,14.1421,1749,14.1421,1750,22.3607,1751,22.3607,1752,22.3607,1753,7.07107,1754,7.07107,1755,7.07107,1756,10,1757,10,1758,10,1759,14.1421,1760,14.1421,1761,14.1421,1762,22.3607,1763,22.3607,1764,22.3607,1765,7.07107,1766,7.07107,1767,7.07107,1768,10,1769,10,1770,10,1771,14.1421,1772,14.1421,1773,14.1421,1774,22.3607,1775,22.3607,1776,22.3607,1777,7.07107,1778,7.07107,1779,7.07107,1780,10,1781,10,1782,10,1783,14.1421,1784,14.1421,1785,14.1421,1786,22.3607,1787,22.3607,1788,22.3607,1789,7.07107,1790,7.07107,1791,7.07107,1792,10,1793,10,1794,10,1795,14.1421,1796,14.1421,1797,14.1421,1798,22.3607,1799,22.3607,1800,22.3607,1801,7.07107,1802,7.07107,1803,7.07107,1804,10,1805,10,1806,10,1807,14.1421,1808,14.1421,1809,14.1421,1810,22.3607,1811,22.3607,1812,22.3607,1813,7.07107,1814,7.07107,1815,7.07107,1816,10,1817,10,1818,10,1819,14.1421,1820,14.1421,1821,14.1421,1822,22.3607,1823,22.3607,1824,22.3607,1825,7.07107,1826,7.07107,1827,7.07107,1828,10,1829,10,1830,10,1831,14.1421,1832,14.1421,1833,14.1421,1834,22.3607,1835,22.3607,1836,22.3607,1837,7.07107,1838,7.07107,1839,7.07107,1840,10,1841,10,1842,10,1843,14.1421,1844,14.1421,1845,14.1421,1846,22.3607,1847,22.3607,1848,22.3607,1849,7.07107,1850,7.07107,1851,7.07107,1852,10,1853,10,1854,10,1855,14.1421,1856,14.1421,1857,14.1421,1858,22.3607,1859,22.3607,1860,22.3607,1861,7.07107,1862,7.07107,1863,7.07107,1864,10,1865,10,1866,10,1867,14.1421,1868,14.1421,1869,14.1421,1870,22.3607,1871,22.3607,1872,22.3607,1873,7.07107,1874,7.07107,1875,7.07107,1876,10,1877,10,1878,10,1879,14.1421,1880,14.1421,1881,14.1421,1882,22.3607,1883,22.3607,1884,22.3607,1885,7.07107,1886,7.07107,1887,7.07107,1888,10,1889,10,1890,10,1891,14.1421,1892,14.1421,1893,14.1421,1894,22.3607,1895,22.3607,1896,22.3607,1897,7.07107,1898,7.07107,1899,7.07107,1900,10,1901,10,1902,10,1903,14.1421,1904,14.1421,1905,14.1421,1906,22.3607,1907,22.3607,1908,22.3607,1909,7.07107,1910,7.07107,1911,7.07107,1912,10,1913,10,1914,10,1915,14.1421,1916,14.1421,1917,14.1421,1918,22.3607,1919,22.3607,1920,22.3607,1921,7.07107,1922,7.07107,1923,7.07107,1924,10,1925,10,1926,10,1927,14.1421,1928,14.1421,1929,14.1421,1930,22.3607,1931,22.3607,1932,22.3607,1933,7.07107,1934,7.07107,1935,7.07107,1936,10,1937,10,1938,10,1939,14.1421,1940,14.1421,1941,14.1421,1942,22.3607,1943,22.3607,1944,22.3607,1945,7.07107,1946,7.07107,1947,7.07107,1948,10,1949,10,1950,10,1951,14.1421,1952,14.1421,1953,14.1421,1954,22.3607,1955,22.3607,1956,22.3607,1957,7.07107,1958,7.07107,1959,7.07107,1960,10,1961,10,1962,10,1963,14.1421,1964,14.1421,1965,14.1421,1966,22.3607,1967,22.3607,1968,22.3607,1969,7.07107,1970,7.07107,1971,7.07107,1972,10,1973,10,1974,10,1975,14.1421,1976,14.1421,1977,14.1421,1978,22.3607,1979,22.3607,1980,22.3607,1981,7.07107,1982,7.07107,1983,7.07107,1984,10,1985,10,1986,10,1987,14.1421,1988,14.1421,1989,14.1421,1990,22.3607,1991,22.3607,1992,22.3607,1993,7.07107,1994,7.07107,1995,7.07107,1996,10,1997,10,1998,10,1999,14.1421,2000,14.1421,2001,14.1421,2002,22.3607,2003,22.3607,2004,22.3607,2005,7.07107,2006,7.07107,2007,7.07107,2008,10,2009,10,2010,10,2011,14.1421,2012,14.1421,2013,14.1421,2014,22.3607,2015,22.3607,2016,22.3607,2017,7.07107,2018,7.07107,2019,7.07107,2020,10,2021,10,2022,10,2023,14.1421,2024,14.1421,2025,14.1421,2026,22.3607,2027,22.3607,2028,22.3607,2029,7.07107,2030,7.07107,2031,7.07107,2032,10,2033,10,2034,10,2035,14.1421,2036,14.1421,2037,14.1421,2038,22.3607,2039,22.3607,2040,22.3607,2041,7.07107,2042,7.07107,2043,7.07107,2044,10,2045,10,2046,10,2047,14.1421,2048,14.1421,2049,14.1421,2050,22.3607,2051,22.3607,2052,22.3607,2053,7.07107,2054,7.07107,2055,7.07107,2056,10,2057,10,2058,10,2059,14.1421,2060,14.1421,2061,14.1421,2062,22.3607,2063,22.3607,2064,22.3607,2065,7.07107,2066,7.07107,2067,7.07107,2068,10,2069,10,2070,10,2071,14.1421,2072,14.1421,2073,14.1421,2074,22.3607,2075,22.3607,2076,22.3607,2077,7.07107,2078,7.07107,2079,7.07107,2080,10,2081,10,2082,10,2083,14.1421,2084,14.1421,2085,14.1421,2086,22.3607,2087,22.3607,2088,22.3607,2089,7.07107,2090,7.07107,2091,7.07107,2092,10,2093,10,2094,10,2095,14.1421,2096,14.1421,2097,14.1421,2098,22.3607,2099,22.3607,2100,22.3607,2101,7.07107,2102,7.07107,2103,7.07107,2104,10,2105,10,2106,10,2107,14.1421,2108,14.1421,2109,14.1421,2110,22.3607,2111,22.3607,2112,22.3607,2113,7.07107,2114,7.07107,2115,7.07107,2116,10,2117,10,2118,10,2119,14.1421,2120,14.1421,2121,14.1421,2122,22.3607,2123,22.3607,2124,22.3607,2125,7.07107,2126,7.07107,2127,7.07107,2128,10,2129,10,2130,10,2131,14.1421,2132,14.1421,2133,14.1421,2134,22.3607,2135,22.3607,2136,22.3607,2137,7.07107,2138,7.07107,2139,7.07107,2140,10,2141,10,2142,10,2143,14.1421,2144,14.1421,2145,14.1421,2146,22.3607,2147,22.3607,2148,22.3607,2149,7.07107,2150,7.07107,2151,7.07107,2152,10,2153,10,2154,10,2155,14.1421,2156,14.1421,2157,14.1421,2158,22.3607,2159,22.3607,2160,22.3607,2161,7.07107,2162,7.07107,2163,7.07107,2164,10,2165,10,2166,10,2167,14.1421,2168,14.1421,2169,14.1421,2170,22.3607,2171,22.3607,2172,22.3607,2173,7.07107,2174,7.07107,2175,7.07107,2176,10,2177,10,2178,10,2179,14.1421,2180,14.1421,2181,14.1421,2182,22.3607,2183,22.3607,2184,22.3607,2185,7.07107,2186,7.07107,2187,7.07107,2188,10,2189,10,2190,10,2191,14.1421,2192,14.1421,2193,14.1421,2194,22.3607,2195,22.3607,2196,22.3607,2197,7.07107,2198,7.07107,2199,7.07107,2200,10,2201,10,2202,10,2203,14.1421,2204,14.1421,2205,14.1421,2206,22.3607,2207,22.3607,2208,22.3607,2209,7.07107,2210,7.07107,2211,7.07107,2212,10,2213,10,2214,10,2215,14.1421,2216,14.1421,2217,14.1421,2218,22.3607,2219,22.3607,2220,22.3607,2221,7.07107,2222,7.07107,2223,7.07107,2224,10,2225,10,2226,10,2227,14.1421,2228,14.1421,2229,14.1421,2230,22.3607,2231,22.3607,2232,22.3607,2233,7.07107,2234,7.07107,2235,7.07107,2236,10,2237,10,2238,10,2239,14.1421,2240,14.1421,2241,14.1421,2242,22.3607,2243,22.3607,2244,22.3607,2245,7.07107,2246,7.07107,2247,7.07107,2248,10,2249,10,2250,10,2251,14.1421,2252,14.1421,2253,14.1421,2254,22.3607,2255,22.3607,2256,22.3607,2257,7.07107,2258,7.07107,2259,7.07107,2260,10,2261,10,2262,10,2263,14.1421,2264,14.1421,2265,14.1421,2266,22.3607,2267,22.3607,2268,22.3607,2269,7.07107,2270,7.07107,2271,7.07107,2272,10,2273,10,2274,10,2275,14.1421,2276,14.1421,2277,14.1421,2278,22.3607,2279,22.3607,2280,22.3607,2281,7.07107,2282,7.07107,2283,7.07107,2284,10,2285,10,2286,10,2287,14.1421,2288,14.1421,2289,14.1421,2290,22.3607,2291,22.3607,2292,22.3607,2293,7.07107,2294,7.07107,2295,7.07107,2296,10,2297,10,2298,10,2299,14.1421,2300,14.1421,2301,14.1421,2302,22.3607,2303,22.3607,2304,22.3607,2305,7.07107,2306,7.07107,2307,7.07107,2308,10,2309,10,2310,10,2311,14.1421,2312,14.1421,2313,14.1421,2314,22.3607,2315,22.3607,2316,22.3607,2317,7.07107,2318,7.07107,2319,7.07107,2320,10,2321,10,2322,10,2323,14.1421,2324,14.1421,2325,14.1421,2326,22.3607,2327,22.3607,2328,22.3607,2329,7.07107,2330,7.07107,2331,7.07107,2332,10,2333,10,2334,10,2335,14.1421,2336,14.1421,2337,14.1421,2338,22.3607,2339,22.3607,2340,22.3607,2341,7.07107,2342,7.07107,2343,7.07107,2344,10,2345,10,2346,10,2347,14.1421,2348,14.1421,2349,14.1421,2350,22.3607,2351,22.3607,2352,22.3607,2353,7.07107,2354,7.07107,2355,7.07107,2356,10,2357,10,2358,10,2359,14.1421,2360,14.1421,2361,14.1421,2362,22.3607,2363,22.3607,2364,22.3607,2365,7.07107,2366,7.07107,2367,7.07107,2368,10,2369,10,2370,10,2371,14.1421,2372,14.1421,2373,14.1421,2374,22.3607,2375,22.3607,2376,22.3607,2377,7.07107,2378,7.07107,2379,7.07107,2380,10,2381,10,2382,10,2383,14.1421,2384,14.1421,2385,14.1421,2386,22.3607,2387,22.3607,2388,22.3607,2389,7.07107,2390,7.07107,2391,7.07107,2392,10,2393,10,2394,10,2395,14.1421,2396,14.1421,2397,14.1421,2398,22.3607,2399,22.3607,2400,22.3607,2401,7.07107,2402,7.07107,2403,7.07107,2404,10,2405,10,2406,10,2407,14.1421,2408,14.1421,2409,14.1421,2410,22.3607,2411,22.3607,2412,22.3607,2413,7.07107,2414,7.07107,2415,7.07107,2416,10,2417,10,2418,10,2419,14.1421,2420,14.1421,2421,14.1421,2422,22.3607,2423,22.3607,2424,22.3607,2425,7.07107,2426,7.07107,2427,7.07107,2428,10,2429,10,2430,10,2431,14.1421,2432,14.1421,2433,14.1421,2434,22.3607,2435,22.3607,2436,22.3607,2437,7.07107,2438,7.07107,2439,7.07107,2440,10,2441,10,2442,10,2443,14.1421,2444,14.1421,2445,14.1421,2446,22.3607,2447,22.3607,2448,22.3607,2449,7.07107,2450,7.07107,2451,7.07107,2452,10,2453,10,2454,10,2455,14.1421,2456,14.1421,2457,14.1421,2458,22.3607,2459,22.3607,2460,22.3607,2461,7.07107,2462,7.07107,2463,7.07107,2464,10,2465,10,2466,10,2467,14.1421,2468,14.1421,2469,14.1421,2470,22.3607,2471,22.3607,2472,22.3607,2473,7.07107,2474,7.07107,2475,7.07107,2476,10,2477,10,2478,10,2479,14.1421,2480,14.1421,2481,14.1421,2482,22.3607,2483,22.3607,2484,22.3607,2485,7.07107,2486,7.07107,2487,7.07107,2488,10,2489,10,2490,10,2491,14.1421,2492,14.1421,2493,14.1421,2494,22.3607,2495,22.3607,2496,22.3607,2497,7.07107,2498,7.07107,2499,7.07107,2500,10,2501,10,2502,10,2503,14.1421,2504,14.1421,2505,14.1421,2506,22.3607,2507,22.3607,2508,22.3607,2509,7.07107,2510,7.07107,2511,7.07107,2512,10,2513,10,2514,10,2515,14.1421,2516,14.1421,2517,14.1421,2518,22.3607,2519,22.3607,2520,22.3607,2521,7.07107,2522,7.07107,2523,7.07107,2524,10,2525,10,2526,10,2527,14.1421,2528,14.1421,2529,14.1421,2530,22.3607,2531,22.3607,2532,22.3607,2533,7.07107,2534,7.07107,2535,7.07107,2536,10,2537,10,2538,10,2539,14.1421,2540,14.1421,2541,14.1421,2542,22.3607,2543,22.3607,2544,22.3607,2545,7.07107,2546,7.07107,2547,7.07107,2548,10,2549,10,2550,10,2551,14.1421,2552,14.1421,2553,14.1421,2554,22.3607,2555,22.3607,2556,22.3607,2557,7.07107,2558,7.07107,2559,7.07107,2560,10,2561,10,2562,10,2563,14.1421,2564,14.1421,2565,14.1421,2566,22.3607,2567,22.3607,2568,22.3607,2569,7.07107,2570,7.07107,2571,7.07107,2572,10,2573,10,2574,10,2575,14.1421,2576,14.1421,2577,14.1421,2578,22.3607,2579,22.3607,2580,22.3607,2581,7.07107,2582,7.07107,2583,7.07107,2584,10,2585,10,2586,10,2587,14.1421,2588,14.1421,2589,14.1421,2590,22.3607,2591,22.3607,2592,22.3607,2593,7.07107,2594,7.07107,2595,7.07107,2596,10,2597,10,2598,10,2599,14.1421,2600,14.1421,2601,14.1421,2602,22.3607,2603,22.3607,2604,22.3607)
.param VSET=table(run,1,0.414832,2,0.414832,3,0.414832,4,0.611815,5,0.611815,6,0.611815,7,0.892674,8,0.892674,9,0.892674,10,1.45548,11,1.45548,12,1.45548,13,0.414832,14,0.414832,15,0.414832,16,0.611815,17,0.611815,18,0.611815,19,0.892674,20,0.892674,21,0.892674,22,1.45548,23,1.45548,24,1.45548,25,0.414832,26,0.414832,27,0.414832,28,0.611815,29,0.611815,30,0.611815,31,0.892674,32,0.892674,33,0.892674,34,1.45548,35,1.45548,36,1.45548,37,0.414832,38,0.414832,39,0.414832,40,0.611815,41,0.611815,42,0.611815,43,0.892674,44,0.892674,45,0.892674,46,1.45548,47,1.45548,48,1.45548,49,0.414832,50,0.414832,51,0.414832,52,0.611815,53,0.611815,54,0.611815,55,0.892674,56,0.892674,57,0.892674,58,1.45548,59,1.45548,60,1.45548,61,0.414832,62,0.414832,63,0.414832,64,0.611815,65,0.611815,66,0.611815,67,0.892674,68,0.892674,69,0.892674,70,1.45548,71,1.45548,72,1.45548,73,0.414832,74,0.414832,75,0.414832,76,0.611815,77,0.611815,78,0.611815,79,0.892674,80,0.892674,81,0.892674,82,1.45548,83,1.45548,84,1.45548,85,0.414832,86,0.414832,87,0.414832,88,0.611815,89,0.611815,90,0.611815,91,0.892674,92,0.892674,93,0.892674,94,1.45548,95,1.45548,96,1.45548,97,0.414832,98,0.414832,99,0.414832,100,0.611815,101,0.611815,102,0.611815,103,0.892674,104,0.892674,105,0.892674,106,1.45548,107,1.45548,108,1.45548,109,0.414832,110,0.414832,111,0.414832,112,0.611815,113,0.611815,114,0.611815,115,0.892674,116,0.892674,117,0.892674,118,1.45548,119,1.45548,120,1.45548,121,0.414832,122,0.414832,123,0.414832,124,0.611815,125,0.611815,126,0.611815,127,0.892674,128,0.892674,129,0.892674,130,1.45548,131,1.45548,132,1.45548,133,0.414832,134,0.414832,135,0.414832,136,0.611815,137,0.611815,138,0.611815,139,0.892674,140,0.892674,141,0.892674,142,1.45548,143,1.45548,144,1.45548,145,0.414832,146,0.414832,147,0.414832,148,0.611815,149,0.611815,150,0.611815,151,0.892674,152,0.892674,153,0.892674,154,1.45548,155,1.45548,156,1.45548,157,0.414832,158,0.414832,159,0.414832,160,0.611815,161,0.611815,162,0.611815,163,0.892674,164,0.892674,165,0.892674,166,1.45548,167,1.45548,168,1.45548,169,0.414832,170,0.414832,171,0.414832,172,0.611815,173,0.611815,174,0.611815,175,0.892674,176,0.892674,177,0.892674,178,1.45548,179,1.45548,180,1.45548,181,0.414832,182,0.414832,183,0.414832,184,0.611815,185,0.611815,186,0.611815,187,0.892674,188,0.892674,189,0.892674,190,1.45548,191,1.45548,192,1.45548,193,0.414832,194,0.414832,195,0.414832,196,0.611815,197,0.611815,198,0.611815,199,0.892674,200,0.892674,201,0.892674,202,1.45548,203,1.45548,204,1.45548,205,0.414832,206,0.414832,207,0.414832,208,0.611815,209,0.611815,210,0.611815,211,0.892674,212,0.892674,213,0.892674,214,1.45548,215,1.45548,216,1.45548,217,0.414832,218,0.414832,219,0.414832,220,0.611815,221,0.611815,222,0.611815,223,0.892674,224,0.892674,225,0.892674,226,1.45548,227,1.45548,228,1.45548,229,0.414832,230,0.414832,231,0.414832,232,0.611815,233,0.611815,234,0.611815,235,0.892674,236,0.892674,237,0.892674,238,1.45548,239,1.45548,240,1.45548,241,0.414832,242,0.414832,243,0.414832,244,0.611815,245,0.611815,246,0.611815,247,0.892674,248,0.892674,249,0.892674,250,1.45548,251,1.45548,252,1.45548,253,0.414832,254,0.414832,255,0.414832,256,0.611815,257,0.611815,258,0.611815,259,0.892674,260,0.892674,261,0.892674,262,1.45548,263,1.45548,264,1.45548,265,0.414832,266,0.414832,267,0.414832,268,0.611815,269,0.611815,270,0.611815,271,0.892674,272,0.892674,273,0.892674,274,1.45548,275,1.45548,276,1.45548,277,0.414832,278,0.414832,279,0.414832,280,0.611815,281,0.611815,282,0.611815,283,0.892674,284,0.892674,285,0.892674,286,1.45548,287,1.45548,288,1.45548,289,0.414832,290,0.414832,291,0.414832,292,0.611815,293,0.611815,294,0.611815,295,0.892674,296,0.892674,297,0.892674,298,1.45548,299,1.45548,300,1.45548,301,0.414832,302,0.414832,303,0.414832,304,0.611815,305,0.611815,306,0.611815,307,0.892674,308,0.892674,309,0.892674,310,1.45548,311,1.45548,312,1.45548,313,0.414832,314,0.414832,315,0.414832,316,0.611815,317,0.611815,318,0.611815,319,0.892674,320,0.892674,321,0.892674,322,1.45548,323,1.45548,324,1.45548,325,0.414832,326,0.414832,327,0.414832,328,0.611815,329,0.611815,330,0.611815,331,0.892674,332,0.892674,333,0.892674,334,1.45548,335,1.45548,336,1.45548,337,0.414832,338,0.414832,339,0.414832,340,0.611815,341,0.611815,342,0.611815,343,0.892674,344,0.892674,345,0.892674,346,1.45548,347,1.45548,348,1.45548,349,0.414832,350,0.414832,351,0.414832,352,0.611815,353,0.611815,354,0.611815,355,0.892674,356,0.892674,357,0.892674,358,1.45548,359,1.45548,360,1.45548,361,0.414832,362,0.414832,363,0.414832,364,0.611815,365,0.611815,366,0.611815,367,0.892674,368,0.892674,369,0.892674,370,1.45548,371,1.45548,372,1.45548,373,0.414832,374,0.414832,375,0.414832,376,0.611815,377,0.611815,378,0.611815,379,0.892674,380,0.892674,381,0.892674,382,1.45548,383,1.45548,384,1.45548,385,0.414832,386,0.414832,387,0.414832,388,0.611815,389,0.611815,390,0.611815,391,0.892674,392,0.892674,393,0.892674,394,1.45548,395,1.45548,396,1.45548,397,0.414832,398,0.414832,399,0.414832,400,0.611815,401,0.611815,402,0.611815,403,0.892674,404,0.892674,405,0.892674,406,1.45548,407,1.45548,408,1.45548,409,0.414832,410,0.414832,411,0.414832,412,0.611815,413,0.611815,414,0.611815,415,0.892674,416,0.892674,417,0.892674,418,1.45548,419,1.45548,420,1.45548,421,0.414832,422,0.414832,423,0.414832,424,0.611815,425,0.611815,426,0.611815,427,0.892674,428,0.892674,429,0.892674,430,1.45548,431,1.45548,432,1.45548,433,0.414832,434,0.414832,435,0.414832,436,0.611815,437,0.611815,438,0.611815,439,0.892674,440,0.892674,441,0.892674,442,1.45548,443,1.45548,444,1.45548,445,0.414832,446,0.414832,447,0.414832,448,0.611815,449,0.611815,450,0.611815,451,0.892674,452,0.892674,453,0.892674,454,1.45548,455,1.45548,456,1.45548,457,0.414832,458,0.414832,459,0.414832,460,0.611815,461,0.611815,462,0.611815,463,0.892674,464,0.892674,465,0.892674,466,1.45548,467,1.45548,468,1.45548,469,0.414832,470,0.414832,471,0.414832,472,0.611815,473,0.611815,474,0.611815,475,0.892674,476,0.892674,477,0.892674,478,1.45548,479,1.45548,480,1.45548,481,0.414832,482,0.414832,483,0.414832,484,0.611815,485,0.611815,486,0.611815,487,0.892674,488,0.892674,489,0.892674,490,1.45548,491,1.45548,492,1.45548,493,0.414832,494,0.414832,495,0.414832,496,0.611815,497,0.611815,498,0.611815,499,0.892674,500,0.892674,501,0.892674,502,1.45548,503,1.45548,504,1.45548,505,0.414832,506,0.414832,507,0.414832,508,0.611815,509,0.611815,510,0.611815,511,0.892674,512,0.892674,513,0.892674,514,1.45548,515,1.45548,516,1.45548,517,0.414832,518,0.414832,519,0.414832,520,0.611815,521,0.611815,522,0.611815,523,0.892674,524,0.892674,525,0.892674,526,1.45548,527,1.45548,528,1.45548,529,0.414832,530,0.414832,531,0.414832,532,0.611815,533,0.611815,534,0.611815,535,0.892674,536,0.892674,537,0.892674,538,1.45548,539,1.45548,540,1.45548,541,0.414832,542,0.414832,543,0.414832,544,0.611815,545,0.611815,546,0.611815,547,0.892674,548,0.892674,549,0.892674,550,1.45548,551,1.45548,552,1.45548,553,0.414832,554,0.414832,555,0.414832,556,0.611815,557,0.611815,558,0.611815,559,0.892674,560,0.892674,561,0.892674,562,1.45548,563,1.45548,564,1.45548,565,0.414832,566,0.414832,567,0.414832,568,0.611815,569,0.611815,570,0.611815,571,0.892674,572,0.892674,573,0.892674,574,1.45548,575,1.45548,576,1.45548,577,0.414832,578,0.414832,579,0.414832,580,0.611815,581,0.611815,582,0.611815,583,0.892674,584,0.892674,585,0.892674,586,1.45548,587,1.45548,588,1.45548,589,0.414832,590,0.414832,591,0.414832,592,0.611815,593,0.611815,594,0.611815,595,0.892674,596,0.892674,597,0.892674,598,1.45548,599,1.45548,600,1.45548,601,0.414832,602,0.414832,603,0.414832,604,0.611815,605,0.611815,606,0.611815,607,0.892674,608,0.892674,609,0.892674,610,1.45548,611,1.45548,612,1.45548,613,0.414832,614,0.414832,615,0.414832,616,0.611815,617,0.611815,618,0.611815,619,0.892674,620,0.892674,621,0.892674,622,1.45548,623,1.45548,624,1.45548,625,0.414832,626,0.414832,627,0.414832,628,0.611815,629,0.611815,630,0.611815,631,0.892674,632,0.892674,633,0.892674,634,1.45548,635,1.45548,636,1.45548,637,0.414832,638,0.414832,639,0.414832,640,0.611815,641,0.611815,642,0.611815,643,0.892674,644,0.892674,645,0.892674,646,1.45548,647,1.45548,648,1.45548,649,0.414832,650,0.414832,651,0.414832,652,0.611815,653,0.611815,654,0.611815,655,0.892674,656,0.892674,657,0.892674,658,1.45548,659,1.45548,660,1.45548,661,0.414832,662,0.414832,663,0.414832,664,0.611815,665,0.611815,666,0.611815,667,0.892674,668,0.892674,669,0.892674,670,1.45548,671,1.45548,672,1.45548,673,0.414832,674,0.414832,675,0.414832,676,0.611815,677,0.611815,678,0.611815,679,0.892674,680,0.892674,681,0.892674,682,1.45548,683,1.45548,684,1.45548,685,0.414832,686,0.414832,687,0.414832,688,0.611815,689,0.611815,690,0.611815,691,0.892674,692,0.892674,693,0.892674,694,1.45548,695,1.45548,696,1.45548,697,0.414832,698,0.414832,699,0.414832,700,0.611815,701,0.611815,702,0.611815,703,0.892674,704,0.892674,705,0.892674,706,1.45548,707,1.45548,708,1.45548,709,0.414832,710,0.414832,711,0.414832,712,0.611815,713,0.611815,714,0.611815,715,0.892674,716,0.892674,717,0.892674,718,1.45548,719,1.45548,720,1.45548,721,0.414832,722,0.414832,723,0.414832,724,0.611815,725,0.611815,726,0.611815,727,0.892674,728,0.892674,729,0.892674,730,1.45548,731,1.45548,732,1.45548,733,0.414832,734,0.414832,735,0.414832,736,0.611815,737,0.611815,738,0.611815,739,0.892674,740,0.892674,741,0.892674,742,1.45548,743,1.45548,744,1.45548,745,0.414832,746,0.414832,747,0.414832,748,0.611815,749,0.611815,750,0.611815,751,0.892674,752,0.892674,753,0.892674,754,1.45548,755,1.45548,756,1.45548,757,0.414832,758,0.414832,759,0.414832,760,0.611815,761,0.611815,762,0.611815,763,0.892674,764,0.892674,765,0.892674,766,1.45548,767,1.45548,768,1.45548,769,0.414832,770,0.414832,771,0.414832,772,0.611815,773,0.611815,774,0.611815,775,0.892674,776,0.892674,777,0.892674,778,1.45548,779,1.45548,780,1.45548,781,0.414832,782,0.414832,783,0.414832,784,0.611815,785,0.611815,786,0.611815,787,0.892674,788,0.892674,789,0.892674,790,1.45548,791,1.45548,792,1.45548,793,0.414832,794,0.414832,795,0.414832,796,0.611815,797,0.611815,798,0.611815,799,0.892674,800,0.892674,801,0.892674,802,1.45548,803,1.45548,804,1.45548,805,0.414832,806,0.414832,807,0.414832,808,0.611815,809,0.611815,810,0.611815,811,0.892674,812,0.892674,813,0.892674,814,1.45548,815,1.45548,816,1.45548,817,0.414832,818,0.414832,819,0.414832,820,0.611815,821,0.611815,822,0.611815,823,0.892674,824,0.892674,825,0.892674,826,1.45548,827,1.45548,828,1.45548,829,0.414832,830,0.414832,831,0.414832,832,0.611815,833,0.611815,834,0.611815,835,0.892674,836,0.892674,837,0.892674,838,1.45548,839,1.45548,840,1.45548,841,0.414832,842,0.414832,843,0.414832,844,0.611815,845,0.611815,846,0.611815,847,0.892674,848,0.892674,849,0.892674,850,1.45548,851,1.45548,852,1.45548,853,0.414832,854,0.414832,855,0.414832,856,0.611815,857,0.611815,858,0.611815,859,0.892674,860,0.892674,861,0.892674,862,1.45548,863,1.45548,864,1.45548,865,0.414832,866,0.414832,867,0.414832,868,0.611815,869,0.611815,870,0.611815,871,0.892674,872,0.892674,873,0.892674,874,1.45548,875,1.45548,876,1.45548,877,0.414832,878,0.414832,879,0.414832,880,0.611815,881,0.611815,882,0.611815,883,0.892674,884,0.892674,885,0.892674,886,1.45548,887,1.45548,888,1.45548,889,0.414832,890,0.414832,891,0.414832,892,0.611815,893,0.611815,894,0.611815,895,0.892674,896,0.892674,897,0.892674,898,1.45548,899,1.45548,900,1.45548,901,0.414832,902,0.414832,903,0.414832,904,0.611815,905,0.611815,906,0.611815,907,0.892674,908,0.892674,909,0.892674,910,1.45548,911,1.45548,912,1.45548,913,0.414832,914,0.414832,915,0.414832,916,0.611815,917,0.611815,918,0.611815,919,0.892674,920,0.892674,921,0.892674,922,1.45548,923,1.45548,924,1.45548,925,0.414832,926,0.414832,927,0.414832,928,0.611815,929,0.611815,930,0.611815,931,0.892674,932,0.892674,933,0.892674,934,1.45548,935,1.45548,936,1.45548,937,0.414832,938,0.414832,939,0.414832,940,0.611815,941,0.611815,942,0.611815,943,0.892674,944,0.892674,945,0.892674,946,1.45548,947,1.45548,948,1.45548,949,0.414832,950,0.414832,951,0.414832,952,0.611815,953,0.611815,954,0.611815,955,0.892674,956,0.892674,957,0.892674,958,1.45548,959,1.45548,960,1.45548,961,0.414832,962,0.414832,963,0.414832,964,0.611815,965,0.611815,966,0.611815,967,0.892674,968,0.892674,969,0.892674,970,1.45548,971,1.45548,972,1.45548,973,0.414832,974,0.414832,975,0.414832,976,0.611815,977,0.611815,978,0.611815,979,0.892674,980,0.892674,981,0.892674,982,1.45548,983,1.45548,984,1.45548,985,0.414832,986,0.414832,987,0.414832,988,0.611815,989,0.611815,990,0.611815,991,0.892674,992,0.892674,993,0.892674,994,1.45548,995,1.45548,996,1.45548,997,0.414832,998,0.414832,999,0.414832,1000,0.611815,1001,0.611815,1002,0.611815,1003,0.892674,1004,0.892674,1005,0.892674,1006,1.45548,1007,1.45548,1008,1.45548,1009,0.414832,1010,0.414832,1011,0.414832,1012,0.611815,1013,0.611815,1014,0.611815,1015,0.892674,1016,0.892674,1017,0.892674,1018,1.45548,1019,1.45548,1020,1.45548,1021,0.414832,1022,0.414832,1023,0.414832,1024,0.611815,1025,0.611815,1026,0.611815,1027,0.892674,1028,0.892674,1029,0.892674,1030,1.45548,1031,1.45548,1032,1.45548,1033,0.414832,1034,0.414832,1035,0.414832,1036,0.611815,1037,0.611815,1038,0.611815,1039,0.892674,1040,0.892674,1041,0.892674,1042,1.45548,1043,1.45548,1044,1.45548,1045,0.414832,1046,0.414832,1047,0.414832,1048,0.611815,1049,0.611815,1050,0.611815,1051,0.892674,1052,0.892674,1053,0.892674,1054,1.45548,1055,1.45548,1056,1.45548,1057,0.414832,1058,0.414832,1059,0.414832,1060,0.611815,1061,0.611815,1062,0.611815,1063,0.892674,1064,0.892674,1065,0.892674,1066,1.45548,1067,1.45548,1068,1.45548,1069,0.414832,1070,0.414832,1071,0.414832,1072,0.611815,1073,0.611815,1074,0.611815,1075,0.892674,1076,0.892674,1077,0.892674,1078,1.45548,1079,1.45548,1080,1.45548,1081,0.414832,1082,0.414832,1083,0.414832,1084,0.611815,1085,0.611815,1086,0.611815,1087,0.892674,1088,0.892674,1089,0.892674,1090,1.45548,1091,1.45548,1092,1.45548,1093,0.414832,1094,0.414832,1095,0.414832,1096,0.611815,1097,0.611815,1098,0.611815,1099,0.892674,1100,0.892674,1101,0.892674,1102,1.45548,1103,1.45548,1104,1.45548,1105,0.414832,1106,0.414832,1107,0.414832,1108,0.611815,1109,0.611815,1110,0.611815,1111,0.892674,1112,0.892674,1113,0.892674,1114,1.45548,1115,1.45548,1116,1.45548,1117,0.414832,1118,0.414832,1119,0.414832,1120,0.611815,1121,0.611815,1122,0.611815,1123,0.892674,1124,0.892674,1125,0.892674,1126,1.29247,1127,1.29247,1128,1.29247,1129,0.414832,1130,0.414832,1131,0.414832,1132,0.611815,1133,0.611815,1134,0.611815,1135,0.892674,1136,0.892674,1137,0.892674,1138,1.29247,1139,1.29247,1140,1.29247,1141,0.414832,1142,0.414832,1143,0.414832,1144,0.611815,1145,0.611815,1146,0.611815,1147,0.892674,1148,0.892674,1149,0.892674,1150,1.29247,1151,1.29247,1152,1.29247,1153,0.414832,1154,0.414832,1155,0.414832,1156,0.611815,1157,0.611815,1158,0.611815,1159,0.892674,1160,0.892674,1161,0.892674,1162,1.29247,1163,1.29247,1164,1.29247,1165,0.414832,1166,0.414832,1167,0.414832,1168,0.611815,1169,0.611815,1170,0.611815,1171,0.892674,1172,0.892674,1173,0.892674,1174,1.29247,1175,1.29247,1176,1.29247,1177,0.414832,1178,0.414832,1179,0.414832,1180,0.611815,1181,0.611815,1182,0.611815,1183,0.892674,1184,0.892674,1185,0.892674,1186,1.29247,1187,1.29247,1188,1.29247,1189,0.414832,1190,0.414832,1191,0.414832,1192,0.611815,1193,0.611815,1194,0.611815,1195,0.892674,1196,0.892674,1197,0.892674,1198,1.29247,1199,1.29247,1200,1.29247,1201,0.414832,1202,0.414832,1203,0.414832,1204,0.611815,1205,0.611815,1206,0.611815,1207,0.892674,1208,0.892674,1209,0.892674,1210,1.29247,1211,1.29247,1212,1.29247,1213,0.414832,1214,0.414832,1215,0.414832,1216,0.611815,1217,0.611815,1218,0.611815,1219,0.892674,1220,0.892674,1221,0.892674,1222,1.29247,1223,1.29247,1224,1.29247,1225,0.414832,1226,0.414832,1227,0.414832,1228,0.611815,1229,0.611815,1230,0.611815,1231,0.892674,1232,0.892674,1233,0.892674,1234,1.29247,1235,1.29247,1236,1.29247,1237,0.414832,1238,0.414832,1239,0.414832,1240,0.611815,1241,0.611815,1242,0.611815,1243,0.892674,1244,0.892674,1245,0.892674,1246,1.29247,1247,1.29247,1248,1.29247,1249,0.414832,1250,0.414832,1251,0.414832,1252,0.611815,1253,0.611815,1254,0.611815,1255,0.892674,1256,0.892674,1257,0.892674,1258,1.29247,1259,1.29247,1260,1.29247,1261,0.414832,1262,0.414832,1263,0.414832,1264,0.611815,1265,0.611815,1266,0.611815,1267,0.892674,1268,0.892674,1269,0.892674,1270,1.29247,1271,1.29247,1272,1.29247,1273,0.414832,1274,0.414832,1275,0.414832,1276,0.611815,1277,0.611815,1278,0.611815,1279,0.892674,1280,0.892674,1281,0.892674,1282,1.29247,1283,1.29247,1284,1.29247,1285,0.414832,1286,0.414832,1287,0.414832,1288,0.611815,1289,0.611815,1290,0.611815,1291,0.892674,1292,0.892674,1293,0.892674,1294,1.29247,1295,1.29247,1296,1.29247,1297,0.414832,1298,0.414832,1299,0.414832,1300,0.611815,1301,0.611815,1302,0.611815,1303,0.892674,1304,0.892674,1305,0.892674,1306,1.29247,1307,1.29247,1308,1.29247,1309,0.414832,1310,0.414832,1311,0.414832,1312,0.611815,1313,0.611815,1314,0.611815,1315,0.892674,1316,0.892674,1317,0.892674,1318,1.29247,1319,1.29247,1320,1.29247,1321,0.414832,1322,0.414832,1323,0.414832,1324,0.611815,1325,0.611815,1326,0.611815,1327,0.892674,1328,0.892674,1329,0.892674,1330,1.29247,1331,1.29247,1332,1.29247,1333,0.414832,1334,0.414832,1335,0.414832,1336,0.611815,1337,0.611815,1338,0.611815,1339,0.892674,1340,0.892674,1341,0.892674,1342,1.29247,1343,1.29247,1344,1.29247,1345,0.414832,1346,0.414832,1347,0.414832,1348,0.611815,1349,0.611815,1350,0.611815,1351,0.892674,1352,0.892674,1353,0.892674,1354,1.29247,1355,1.29247,1356,1.29247,1357,0.414832,1358,0.414832,1359,0.414832,1360,0.611815,1361,0.611815,1362,0.611815,1363,0.892674,1364,0.892674,1365,0.892674,1366,1.29247,1367,1.29247,1368,1.29247,1369,0.414832,1370,0.414832,1371,0.414832,1372,0.611815,1373,0.611815,1374,0.611815,1375,0.892674,1376,0.892674,1377,0.892674,1378,1.29247,1379,1.29247,1380,1.29247,1381,0.414832,1382,0.414832,1383,0.414832,1384,0.611815,1385,0.611815,1386,0.611815,1387,0.892674,1388,0.892674,1389,0.892674,1390,1.29247,1391,1.29247,1392,1.29247,1393,0.414832,1394,0.414832,1395,0.414832,1396,0.611815,1397,0.611815,1398,0.611815,1399,0.892674,1400,0.892674,1401,0.892674,1402,1.29247,1403,1.29247,1404,1.29247,1405,0.414832,1406,0.414832,1407,0.414832,1408,0.611815,1409,0.611815,1410,0.611815,1411,0.892674,1412,0.892674,1413,0.892674,1414,1.29247,1415,1.29247,1416,1.29247,1417,0.414832,1418,0.414832,1419,0.414832,1420,0.611815,1421,0.611815,1422,0.611815,1423,0.892674,1424,0.892674,1425,0.892674,1426,1.29247,1427,1.29247,1428,1.29247,1429,0.414832,1430,0.414832,1431,0.414832,1432,0.611815,1433,0.611815,1434,0.611815,1435,0.892674,1436,0.892674,1437,0.892674,1438,1.29247,1439,1.29247,1440,1.29247,1441,0.414832,1442,0.414832,1443,0.414832,1444,0.611815,1445,0.611815,1446,0.611815,1447,0.892674,1448,0.892674,1449,0.892674,1450,1.29247,1451,1.29247,1452,1.29247,1453,0.414832,1454,0.414832,1455,0.414832,1456,0.611815,1457,0.611815,1458,0.611815,1459,0.892674,1460,0.892674,1461,0.892674,1462,1.29247,1463,1.29247,1464,1.29247,1465,0.414832,1466,0.414832,1467,0.414832,1468,0.611815,1469,0.611815,1470,0.611815,1471,0.892674,1472,0.892674,1473,0.892674,1474,1.29247,1475,1.29247,1476,1.29247,1477,0.414832,1478,0.414832,1479,0.414832,1480,0.611815,1481,0.611815,1482,0.611815,1483,0.892674,1484,0.892674,1485,0.892674,1486,1.29247,1487,1.29247,1488,1.29247,1489,0.414832,1490,0.414832,1491,0.414832,1492,0.611815,1493,0.611815,1494,0.611815,1495,0.892674,1496,0.892674,1497,0.892674,1498,1.45548,1499,1.45548,1500,1.45548,1501,0.414832,1502,0.414832,1503,0.414832,1504,0.611815,1505,0.611815,1506,0.611815,1507,0.892674,1508,0.892674,1509,0.892674,1510,1.45548,1511,1.45548,1512,1.45548,1513,0.414832,1514,0.414832,1515,0.414832,1516,0.611815,1517,0.611815,1518,0.611815,1519,0.892674,1520,0.892674,1521,0.892674,1522,1.45548,1523,1.45548,1524,1.45548,1525,0.414832,1526,0.414832,1527,0.414832,1528,0.611815,1529,0.611815,1530,0.611815,1531,0.892674,1532,0.892674,1533,0.892674,1534,1.45548,1535,1.45548,1536,1.45548,1537,0.414832,1538,0.414832,1539,0.414832,1540,0.611815,1541,0.611815,1542,0.611815,1543,0.892674,1544,0.892674,1545,0.892674,1546,1.45548,1547,1.45548,1548,1.45548,1549,0.414832,1550,0.414832,1551,0.414832,1552,0.611815,1553,0.611815,1554,0.611815,1555,0.892674,1556,0.892674,1557,0.892674,1558,1.45548,1559,1.45548,1560,1.45548,1561,0.414832,1562,0.414832,1563,0.414832,1564,0.611815,1565,0.611815,1566,0.611815,1567,0.892674,1568,0.892674,1569,0.892674,1570,1.45548,1571,1.45548,1572,1.45548,1573,0.414832,1574,0.414832,1575,0.414832,1576,0.611815,1577,0.611815,1578,0.611815,1579,0.892674,1580,0.892674,1581,0.892674,1582,1.45548,1583,1.45548,1584,1.45548,1585,0.414832,1586,0.414832,1587,0.414832,1588,0.611815,1589,0.611815,1590,0.611815,1591,0.892674,1592,0.892674,1593,0.892674,1594,1.45548,1595,1.45548,1596,1.45548,1597,0.414832,1598,0.414832,1599,0.414832,1600,0.611815,1601,0.611815,1602,0.611815,1603,0.892674,1604,0.892674,1605,0.892674,1606,1.45548,1607,1.45548,1608,1.45548,1609,0.414832,1610,0.414832,1611,0.414832,1612,0.611815,1613,0.611815,1614,0.611815,1615,0.892674,1616,0.892674,1617,0.892674,1618,1.45548,1619,1.45548,1620,1.45548,1621,0.414832,1622,0.414832,1623,0.414832,1624,0.611815,1625,0.611815,1626,0.611815,1627,0.892674,1628,0.892674,1629,0.892674,1630,1.45548,1631,1.45548,1632,1.45548,1633,0.414832,1634,0.414832,1635,0.414832,1636,0.611815,1637,0.611815,1638,0.611815,1639,0.892674,1640,0.892674,1641,0.892674,1642,1.45548,1643,1.45548,1644,1.45548,1645,0.414832,1646,0.414832,1647,0.414832,1648,0.611815,1649,0.611815,1650,0.611815,1651,0.892674,1652,0.892674,1653,0.892674,1654,1.45548,1655,1.45548,1656,1.45548,1657,0.414832,1658,0.414832,1659,0.414832,1660,0.611815,1661,0.611815,1662,0.611815,1663,0.892674,1664,0.892674,1665,0.892674,1666,1.45548,1667,1.45548,1668,1.45548,1669,0.414832,1670,0.414832,1671,0.414832,1672,0.611815,1673,0.611815,1674,0.611815,1675,0.892674,1676,0.892674,1677,0.892674,1678,1.45548,1679,1.45548,1680,1.45548,1681,0.414832,1682,0.414832,1683,0.414832,1684,0.611815,1685,0.611815,1686,0.611815,1687,0.892674,1688,0.892674,1689,0.892674,1690,1.45548,1691,1.45548,1692,1.45548,1693,0.414832,1694,0.414832,1695,0.414832,1696,0.611815,1697,0.611815,1698,0.611815,1699,0.892674,1700,0.892674,1701,0.892674,1702,1.45548,1703,1.45548,1704,1.45548,1705,0.414832,1706,0.414832,1707,0.414832,1708,0.611815,1709,0.611815,1710,0.611815,1711,0.892674,1712,0.892674,1713,0.892674,1714,1.45548,1715,1.45548,1716,1.45548,1717,0.414832,1718,0.414832,1719,0.414832,1720,0.611815,1721,0.611815,1722,0.611815,1723,0.892674,1724,0.892674,1725,0.892674,1726,1.45548,1727,1.45548,1728,1.45548,1729,0.414832,1730,0.414832,1731,0.414832,1732,0.611815,1733,0.611815,1734,0.611815,1735,0.892674,1736,0.892674,1737,0.892674,1738,1.45548,1739,1.45548,1740,1.45548,1741,0.414832,1742,0.414832,1743,0.414832,1744,0.611815,1745,0.611815,1746,0.611815,1747,0.892674,1748,0.892674,1749,0.892674,1750,1.45548,1751,1.45548,1752,1.45548,1753,0.414832,1754,0.414832,1755,0.414832,1756,0.611815,1757,0.611815,1758,0.611815,1759,0.892674,1760,0.892674,1761,0.892674,1762,1.45548,1763,1.45548,1764,1.45548,1765,0.414832,1766,0.414832,1767,0.414832,1768,0.611815,1769,0.611815,1770,0.611815,1771,0.892674,1772,0.892674,1773,0.892674,1774,1.45548,1775,1.45548,1776,1.45548,1777,0.414832,1778,0.414832,1779,0.414832,1780,0.611815,1781,0.611815,1782,0.611815,1783,0.892674,1784,0.892674,1785,0.892674,1786,1.45548,1787,1.45548,1788,1.45548,1789,0.414832,1790,0.414832,1791,0.414832,1792,0.611815,1793,0.611815,1794,0.611815,1795,0.892674,1796,0.892674,1797,0.892674,1798,1.45548,1799,1.45548,1800,1.45548,1801,0.414832,1802,0.414832,1803,0.414832,1804,0.611815,1805,0.611815,1806,0.611815,1807,0.892674,1808,0.892674,1809,0.892674,1810,1.45548,1811,1.45548,1812,1.45548,1813,0.414832,1814,0.414832,1815,0.414832,1816,0.611815,1817,0.611815,1818,0.611815,1819,0.892674,1820,0.892674,1821,0.892674,1822,1.45548,1823,1.45548,1824,1.45548,1825,0.414832,1826,0.414832,1827,0.414832,1828,0.611815,1829,0.611815,1830,0.611815,1831,0.892674,1832,0.892674,1833,0.892674,1834,1.45548,1835,1.45548,1836,1.45548,1837,0.414832,1838,0.414832,1839,0.414832,1840,0.611815,1841,0.611815,1842,0.611815,1843,0.892674,1844,0.892674,1845,0.892674,1846,1.45548,1847,1.45548,1848,1.45548,1849,0.414832,1850,0.414832,1851,0.414832,1852,0.611815,1853,0.611815,1854,0.611815,1855,0.892674,1856,0.892674,1857,0.892674,1858,1.45548,1859,1.45548,1860,1.45548,1861,0.414832,1862,0.414832,1863,0.414832,1864,0.611815,1865,0.611815,1866,0.611815,1867,0.892674,1868,0.892674,1869,0.892674,1870,1.45548,1871,1.45548,1872,1.45548,1873,0.414832,1874,0.414832,1875,0.414832,1876,0.611815,1877,0.611815,1878,0.611815,1879,0.892674,1880,0.892674,1881,0.892674,1882,1.45548,1883,1.45548,1884,1.45548,1885,0.414832,1886,0.414832,1887,0.414832,1888,0.611815,1889,0.611815,1890,0.611815,1891,0.892674,1892,0.892674,1893,0.892674,1894,1.45548,1895,1.45548,1896,1.45548,1897,0.414832,1898,0.414832,1899,0.414832,1900,0.611815,1901,0.611815,1902,0.611815,1903,0.892674,1904,0.892674,1905,0.892674,1906,1.45548,1907,1.45548,1908,1.45548,1909,0.414832,1910,0.414832,1911,0.414832,1912,0.611815,1913,0.611815,1914,0.611815,1915,0.892674,1916,0.892674,1917,0.892674,1918,1.45548,1919,1.45548,1920,1.45548,1921,0.414832,1922,0.414832,1923,0.414832,1924,0.611815,1925,0.611815,1926,0.611815,1927,0.892674,1928,0.892674,1929,0.892674,1930,1.45548,1931,1.45548,1932,1.45548,1933,0.414832,1934,0.414832,1935,0.414832,1936,0.611815,1937,0.611815,1938,0.611815,1939,0.892674,1940,0.892674,1941,0.892674,1942,1.45548,1943,1.45548,1944,1.45548,1945,0.414832,1946,0.414832,1947,0.414832,1948,0.611815,1949,0.611815,1950,0.611815,1951,0.892674,1952,0.892674,1953,0.892674,1954,1.45548,1955,1.45548,1956,1.45548,1957,0.414832,1958,0.414832,1959,0.414832,1960,0.611815,1961,0.611815,1962,0.611815,1963,0.892674,1964,0.892674,1965,0.892674,1966,1.45548,1967,1.45548,1968,1.45548,1969,0.414832,1970,0.414832,1971,0.414832,1972,0.611815,1973,0.611815,1974,0.611815,1975,0.892674,1976,0.892674,1977,0.892674,1978,1.45548,1979,1.45548,1980,1.45548,1981,0.414832,1982,0.414832,1983,0.414832,1984,0.611815,1985,0.611815,1986,0.611815,1987,0.892674,1988,0.892674,1989,0.892674,1990,1.45548,1991,1.45548,1992,1.45548,1993,0.414832,1994,0.414832,1995,0.414832,1996,0.611815,1997,0.611815,1998,0.611815,1999,0.892674,2000,0.892674,2001,0.892674,2002,1.45548,2003,1.45548,2004,1.45548,2005,0.414832,2006,0.414832,2007,0.414832,2008,0.611815,2009,0.611815,2010,0.611815,2011,0.892674,2012,0.892674,2013,0.892674,2014,1.45548,2015,1.45548,2016,1.45548,2017,0.414832,2018,0.414832,2019,0.414832,2020,0.611815,2021,0.611815,2022,0.611815,2023,0.892674,2024,0.892674,2025,0.892674,2026,1.45548,2027,1.45548,2028,1.45548,2029,0.414832,2030,0.414832,2031,0.414832,2032,0.611815,2033,0.611815,2034,0.611815,2035,0.892674,2036,0.892674,2037,0.892674,2038,1.45548,2039,1.45548,2040,1.45548,2041,0.414832,2042,0.414832,2043,0.414832,2044,0.611815,2045,0.611815,2046,0.611815,2047,0.892674,2048,0.892674,2049,0.892674,2050,1.45548,2051,1.45548,2052,1.45548,2053,0.414832,2054,0.414832,2055,0.414832,2056,0.611815,2057,0.611815,2058,0.611815,2059,0.892674,2060,0.892674,2061,0.892674,2062,1.45548,2063,1.45548,2064,1.45548,2065,0.414832,2066,0.414832,2067,0.414832,2068,0.611815,2069,0.611815,2070,0.611815,2071,0.892674,2072,0.892674,2073,0.892674,2074,1.45548,2075,1.45548,2076,1.45548,2077,0.414832,2078,0.414832,2079,0.414832,2080,0.611815,2081,0.611815,2082,0.611815,2083,0.892674,2084,0.892674,2085,0.892674,2086,1.45548,2087,1.45548,2088,1.45548,2089,0.414832,2090,0.414832,2091,0.414832,2092,0.611815,2093,0.611815,2094,0.611815,2095,0.892674,2096,0.892674,2097,0.892674,2098,1.45548,2099,1.45548,2100,1.45548,2101,0.414832,2102,0.414832,2103,0.414832,2104,0.611815,2105,0.611815,2106,0.611815,2107,0.892674,2108,0.892674,2109,0.892674,2110,1.45548,2111,1.45548,2112,1.45548,2113,0.414832,2114,0.414832,2115,0.414832,2116,0.611815,2117,0.611815,2118,0.611815,2119,0.892674,2120,0.892674,2121,0.892674,2122,1.45548,2123,1.45548,2124,1.45548,2125,0.414832,2126,0.414832,2127,0.414832,2128,0.611815,2129,0.611815,2130,0.611815,2131,0.892674,2132,0.892674,2133,0.892674,2134,1.45548,2135,1.45548,2136,1.45548,2137,0.414832,2138,0.414832,2139,0.414832,2140,0.611815,2141,0.611815,2142,0.611815,2143,0.892674,2144,0.892674,2145,0.892674,2146,1.45548,2147,1.45548,2148,1.45548,2149,0.414832,2150,0.414832,2151,0.414832,2152,0.611815,2153,0.611815,2154,0.611815,2155,0.892674,2156,0.892674,2157,0.892674,2158,1.45548,2159,1.45548,2160,1.45548,2161,0.414832,2162,0.414832,2163,0.414832,2164,0.611815,2165,0.611815,2166,0.611815,2167,0.892674,2168,0.892674,2169,0.892674,2170,1.45548,2171,1.45548,2172,1.45548,2173,0.414832,2174,0.414832,2175,0.414832,2176,0.611815,2177,0.611815,2178,0.611815,2179,0.892674,2180,0.892674,2181,0.892674,2182,1.45548,2183,1.45548,2184,1.45548,2185,0.414832,2186,0.414832,2187,0.414832,2188,0.611815,2189,0.611815,2190,0.611815,2191,0.892674,2192,0.892674,2193,0.892674,2194,1.45548,2195,1.45548,2196,1.45548,2197,0.414832,2198,0.414832,2199,0.414832,2200,0.611815,2201,0.611815,2202,0.611815,2203,0.892674,2204,0.892674,2205,0.892674,2206,1.45548,2207,1.45548,2208,1.45548,2209,0.414832,2210,0.414832,2211,0.414832,2212,0.611815,2213,0.611815,2214,0.611815,2215,0.892674,2216,0.892674,2217,0.892674,2218,1.45548,2219,1.45548,2220,1.45548,2221,0.414832,2222,0.414832,2223,0.414832,2224,0.611815,2225,0.611815,2226,0.611815,2227,0.892674,2228,0.892674,2229,0.892674,2230,1.45548,2231,1.45548,2232,1.45548,2233,0.414832,2234,0.414832,2235,0.414832,2236,0.611815,2237,0.611815,2238,0.611815,2239,0.892674,2240,0.892674,2241,0.892674,2242,1.45548,2243,1.45548,2244,1.45548,2245,0.414832,2246,0.414832,2247,0.414832,2248,0.611815,2249,0.611815,2250,0.611815,2251,0.892674,2252,0.892674,2253,0.892674,2254,1.45548,2255,1.45548,2256,1.45548,2257,0.414832,2258,0.414832,2259,0.414832,2260,0.611815,2261,0.611815,2262,0.611815,2263,0.892674,2264,0.892674,2265,0.892674,2266,1.45548,2267,1.45548,2268,1.45548,2269,0.414832,2270,0.414832,2271,0.414832,2272,0.611815,2273,0.611815,2274,0.611815,2275,0.892674,2276,0.892674,2277,0.892674,2278,1.45548,2279,1.45548,2280,1.45548,2281,0.414832,2282,0.414832,2283,0.414832,2284,0.611815,2285,0.611815,2286,0.611815,2287,0.892674,2288,0.892674,2289,0.892674,2290,1.45548,2291,1.45548,2292,1.45548,2293,0.414832,2294,0.414832,2295,0.414832,2296,0.611815,2297,0.611815,2298,0.611815,2299,0.892674,2300,0.892674,2301,0.892674,2302,1.45548,2303,1.45548,2304,1.45548,2305,0.414832,2306,0.414832,2307,0.414832,2308,0.611815,2309,0.611815,2310,0.611815,2311,0.892674,2312,0.892674,2313,0.892674,2314,1.45548,2315,1.45548,2316,1.45548,2317,0.414832,2318,0.414832,2319,0.414832,2320,0.611815,2321,0.611815,2322,0.611815,2323,0.892674,2324,0.892674,2325,0.892674,2326,1.45548,2327,1.45548,2328,1.45548,2329,0.414832,2330,0.414832,2331,0.414832,2332,0.611815,2333,0.611815,2334,0.611815,2335,0.892674,2336,0.892674,2337,0.892674,2338,1.45548,2339,1.45548,2340,1.45548,2341,0.414832,2342,0.414832,2343,0.414832,2344,0.611815,2345,0.611815,2346,0.611815,2347,0.892674,2348,0.892674,2349,0.892674,2350,1.45548,2351,1.45548,2352,1.45548,2353,0.414832,2354,0.414832,2355,0.414832,2356,0.611815,2357,0.611815,2358,0.611815,2359,0.892674,2360,0.892674,2361,0.892674,2362,1.45548,2363,1.45548,2364,1.45548,2365,0.414832,2366,0.414832,2367,0.414832,2368,0.611815,2369,0.611815,2370,0.611815,2371,0.892674,2372,0.892674,2373,0.892674,2374,1.45548,2375,1.45548,2376,1.45548,2377,0.414832,2378,0.414832,2379,0.414832,2380,0.611815,2381,0.611815,2382,0.611815,2383,0.892674,2384,0.892674,2385,0.892674,2386,1.45548,2387,1.45548,2388,1.45548,2389,0.414832,2390,0.414832,2391,0.414832,2392,0.611815,2393,0.611815,2394,0.611815,2395,0.892674,2396,0.892674,2397,0.892674,2398,1.45548,2399,1.45548,2400,1.45548,2401,0.414832,2402,0.414832,2403,0.414832,2404,0.611815,2405,0.611815,2406,0.611815,2407,0.892674,2408,0.892674,2409,0.892674,2410,1.45548,2411,1.45548,2412,1.45548,2413,0.414832,2414,0.414832,2415,0.414832,2416,0.611815,2417,0.611815,2418,0.611815,2419,0.892674,2420,0.892674,2421,0.892674,2422,1.45548,2423,1.45548,2424,1.45548,2425,0.414832,2426,0.414832,2427,0.414832,2428,0.611815,2429,0.611815,2430,0.611815,2431,0.892674,2432,0.892674,2433,0.892674,2434,1.45548,2435,1.45548,2436,1.45548,2437,0.414832,2438,0.414832,2439,0.414832,2440,0.611815,2441,0.611815,2442,0.611815,2443,0.892674,2444,0.892674,2445,0.892674,2446,1.45548,2447,1.45548,2448,1.45548,2449,0.414832,2450,0.414832,2451,0.414832,2452,0.611815,2453,0.611815,2454,0.611815,2455,0.892674,2456,0.892674,2457,0.892674,2458,1.45548,2459,1.45548,2460,1.45548,2461,0.414832,2462,0.414832,2463,0.414832,2464,0.611815,2465,0.611815,2466,0.611815,2467,0.892674,2468,0.892674,2469,0.892674,2470,1.45548,2471,1.45548,2472,1.45548,2473,0.414832,2474,0.414832,2475,0.414832,2476,0.611815,2477,0.611815,2478,0.611815,2479,0.892674,2480,0.892674,2481,0.892674,2482,1.45548,2483,1.45548,2484,1.45548,2485,0.414832,2486,0.414832,2487,0.414832,2488,0.611815,2489,0.611815,2490,0.611815,2491,0.892674,2492,0.892674,2493,0.892674,2494,1.45548,2495,1.45548,2496,1.45548,2497,0.414832,2498,0.414832,2499,0.414832,2500,0.611815,2501,0.611815,2502,0.611815,2503,0.892674,2504,0.892674,2505,0.892674,2506,1.45548,2507,1.45548,2508,1.45548,2509,0.414832,2510,0.414832,2511,0.414832,2512,0.611815,2513,0.611815,2514,0.611815,2515,0.892674,2516,0.892674,2517,0.892674,2518,1.45548,2519,1.45548,2520,1.45548,2521,0.414832,2522,0.414832,2523,0.414832,2524,0.611815,2525,0.611815,2526,0.611815,2527,0.892674,2528,0.892674,2529,0.892674,2530,1.45548,2531,1.45548,2532,1.45548,2533,0.414832,2534,0.414832,2535,0.414832,2536,0.611815,2537,0.611815,2538,0.611815,2539,0.892674,2540,0.892674,2541,0.892674,2542,1.45548,2543,1.45548,2544,1.45548,2545,0.414832,2546,0.414832,2547,0.414832,2548,0.611815,2549,0.611815,2550,0.611815,2551,0.892674,2552,0.892674,2553,0.892674,2554,1.45548,2555,1.45548,2556,1.45548,2557,0.414832,2558,0.414832,2559,0.414832,2560,0.611815,2561,0.611815,2562,0.611815,2563,0.892674,2564,0.892674,2565,0.892674,2566,1.45548,2567,1.45548,2568,1.45548,2569,0.414832,2570,0.414832,2571,0.414832,2572,0.611815,2573,0.611815,2574,0.611815,2575,0.892674,2576,0.892674,2577,0.892674,2578,1.45548,2579,1.45548,2580,1.45548,2581,0.414832,2582,0.414832,2583,0.414832,2584,0.611815,2585,0.611815,2586,0.611815,2587,0.892674,2588,0.892674,2589,0.892674,2590,1.45548,2591,1.45548,2592,1.45548,2593,0.414832,2594,0.414832,2595,0.414832,2596,0.611815,2597,0.611815,2598,0.611815,2599,0.892674,2600,0.892674,2601,0.892674,2602,1.45548,2603,1.45548,2604,1.45548)
.param DB=table(run,1,2.23607,2,2.23607,3,2.23607,4,2.23607,5,2.23607,6,2.23607,7,1,8,1,9,1,10,1,11,1,12,1,13,2.23607,14,2.23607,15,2.23607,16,2.23607,17,2.23607,18,2.23607,19,1,20,1,21,1,22,1,23,1,24,1,25,2.23607,26,2.23607,27,2.23607,28,2.23607,29,2.23607,30,2.23607,31,1,32,1,33,1,34,1,35,1,36,1,37,2.23607,38,2.23607,39,2.23607,40,2.23607,41,2.23607,42,2.23607,43,1,44,1,45,1,46,1,47,1,48,1,49,2.23607,50,2.23607,51,2.23607,52,2.23607,53,2.23607,54,2.23607,55,1,56,1,57,1,58,1,59,1,60,1,61,2.23607,62,2.23607,63,2.23607,64,2.23607,65,2.23607,66,2.23607,67,1,68,1,69,1,70,1,71,1,72,1,73,2.23607,74,2.23607,75,2.23607,76,2.23607,77,2.23607,78,2.23607,79,1,80,1,81,1,82,1,83,1,84,1,85,2.23607,86,2.23607,87,2.23607,88,2.23607,89,2.23607,90,2.23607,91,1,92,1,93,1,94,1,95,1,96,1,97,2.23607,98,2.23607,99,2.23607,100,2.23607,101,2.23607,102,2.23607,103,1,104,1,105,1,106,1,107,1,108,1,109,2.23607,110,2.23607,111,2.23607,112,2.23607,113,2.23607,114,2.23607,115,1,116,1,117,1,118,1,119,1,120,1,121,2.23607,122,2.23607,123,2.23607,124,2.23607,125,2.23607,126,2.23607,127,1,128,1,129,1,130,1,131,1,132,1,133,2.23607,134,2.23607,135,2.23607,136,2.23607,137,2.23607,138,2.23607,139,1,140,1,141,1,142,1,143,1,144,1,145,2.23607,146,2.23607,147,2.23607,148,2.23607,149,2.23607,150,2.23607,151,1,152,1,153,1,154,1,155,1,156,1,157,2.23607,158,2.23607,159,2.23607,160,2.23607,161,2.23607,162,2.23607,163,1,164,1,165,1,166,1,167,1,168,1,169,2.23607,170,2.23607,171,2.23607,172,2.23607,173,2.23607,174,2.23607,175,1,176,1,177,1,178,1,179,1,180,1,181,2.23607,182,2.23607,183,2.23607,184,2.23607,185,2.23607,186,2.23607,187,1,188,1,189,1,190,1,191,1,192,1,193,2.23607,194,2.23607,195,2.23607,196,2.23607,197,2.23607,198,2.23607,199,1,200,1,201,1,202,1,203,1,204,1,205,2.23607,206,2.23607,207,2.23607,208,2.23607,209,2.23607,210,2.23607,211,1,212,1,213,1,214,1,215,1,216,1,217,2.23607,218,2.23607,219,2.23607,220,2.23607,221,2.23607,222,2.23607,223,1,224,1,225,1,226,1,227,1,228,1,229,2.23607,230,2.23607,231,2.23607,232,2.23607,233,2.23607,234,2.23607,235,1,236,1,237,1,238,1,239,1,240,1,241,2.23607,242,2.23607,243,2.23607,244,2.23607,245,2.23607,246,2.23607,247,1,248,1,249,1,250,1,251,1,252,1,253,2.23607,254,2.23607,255,2.23607,256,2.23607,257,2.23607,258,2.23607,259,1,260,1,261,1,262,1,263,1,264,1,265,2.23607,266,2.23607,267,2.23607,268,2.23607,269,2.23607,270,2.23607,271,1,272,1,273,1,274,1,275,1,276,1,277,2.23607,278,2.23607,279,2.23607,280,2.23607,281,2.23607,282,2.23607,283,1,284,1,285,1,286,1,287,1,288,1,289,2.23607,290,2.23607,291,2.23607,292,2.23607,293,2.23607,294,2.23607,295,1,296,1,297,1,298,1,299,1,300,1,301,2.23607,302,2.23607,303,2.23607,304,2.23607,305,2.23607,306,2.23607,307,1,308,1,309,1,310,1,311,1,312,1,313,2.23607,314,2.23607,315,2.23607,316,2.23607,317,2.23607,318,2.23607,319,1,320,1,321,1,322,1,323,1,324,1,325,2.23607,326,2.23607,327,2.23607,328,2.23607,329,2.23607,330,2.23607,331,1,332,1,333,1,334,1,335,1,336,1,337,2.23607,338,2.23607,339,2.23607,340,2.23607,341,2.23607,342,2.23607,343,1,344,1,345,1,346,1,347,1,348,1,349,2.23607,350,2.23607,351,2.23607,352,2.23607,353,2.23607,354,2.23607,355,1,356,1,357,1,358,1,359,1,360,1,361,2.23607,362,2.23607,363,2.23607,364,2.23607,365,2.23607,366,2.23607,367,1,368,1,369,1,370,1,371,1,372,1,373,2.23607,374,2.23607,375,2.23607,376,2.23607,377,2.23607,378,2.23607,379,1,380,1,381,1,382,1,383,1,384,1,385,2.23607,386,2.23607,387,2.23607,388,2.23607,389,2.23607,390,2.23607,391,1,392,1,393,1,394,1,395,1,396,1,397,2.23607,398,2.23607,399,2.23607,400,2.23607,401,2.23607,402,2.23607,403,1,404,1,405,1,406,1,407,1,408,1,409,2.23607,410,2.23607,411,2.23607,412,2.23607,413,2.23607,414,2.23607,415,1,416,1,417,1,418,1,419,1,420,1,421,2.23607,422,2.23607,423,2.23607,424,2.23607,425,2.23607,426,2.23607,427,1,428,1,429,1,430,1,431,1,432,1,433,2.23607,434,2.23607,435,2.23607,436,2.23607,437,2.23607,438,2.23607,439,1,440,1,441,1,442,1,443,1,444,1,445,2.23607,446,2.23607,447,2.23607,448,2.23607,449,2.23607,450,2.23607,451,1,452,1,453,1,454,1,455,1,456,1,457,2.23607,458,2.23607,459,2.23607,460,2.23607,461,2.23607,462,2.23607,463,1,464,1,465,1,466,1,467,1,468,1,469,2.23607,470,2.23607,471,2.23607,472,2.23607,473,2.23607,474,2.23607,475,1,476,1,477,1,478,1,479,1,480,1,481,2.23607,482,2.23607,483,2.23607,484,2.23607,485,2.23607,486,2.23607,487,1,488,1,489,1,490,1,491,1,492,1,493,2.23607,494,2.23607,495,2.23607,496,2.23607,497,2.23607,498,2.23607,499,1,500,1,501,1,502,1,503,1,504,1,505,2.23607,506,2.23607,507,2.23607,508,2.23607,509,2.23607,510,2.23607,511,1,512,1,513,1,514,1,515,1,516,1,517,2.23607,518,2.23607,519,2.23607,520,2.23607,521,2.23607,522,2.23607,523,1,524,1,525,1,526,1,527,1,528,1,529,2.23607,530,2.23607,531,2.23607,532,2.23607,533,2.23607,534,2.23607,535,1,536,1,537,1,538,1,539,1,540,1,541,2.23607,542,2.23607,543,2.23607,544,2.23607,545,2.23607,546,2.23607,547,1,548,1,549,1,550,1,551,1,552,1,553,2.23607,554,2.23607,555,2.23607,556,2.23607,557,2.23607,558,2.23607,559,1,560,1,561,1,562,1,563,1,564,1,565,2.23607,566,2.23607,567,2.23607,568,2.23607,569,2.23607,570,2.23607,571,1,572,1,573,1,574,1,575,1,576,1,577,2.23607,578,2.23607,579,2.23607,580,2.23607,581,2.23607,582,2.23607,583,1,584,1,585,1,586,1,587,1,588,1,589,2.23607,590,2.23607,591,2.23607,592,2.23607,593,2.23607,594,2.23607,595,1,596,1,597,1,598,1,599,1,600,1,601,2.23607,602,2.23607,603,2.23607,604,2.23607,605,2.23607,606,2.23607,607,1,608,1,609,1,610,1,611,1,612,1,613,2.23607,614,2.23607,615,2.23607,616,2.23607,617,2.23607,618,2.23607,619,1,620,1,621,1,622,1,623,1,624,1,625,2.23607,626,2.23607,627,2.23607,628,2.23607,629,2.23607,630,2.23607,631,1,632,1,633,1,634,1,635,1,636,1,637,2.23607,638,2.23607,639,2.23607,640,2.23607,641,2.23607,642,2.23607,643,1,644,1,645,1,646,1,647,1,648,1,649,2.23607,650,2.23607,651,2.23607,652,2.23607,653,2.23607,654,2.23607,655,1,656,1,657,1,658,1,659,1,660,1,661,2.23607,662,2.23607,663,2.23607,664,2.23607,665,2.23607,666,2.23607,667,1,668,1,669,1,670,1,671,1,672,1,673,2.23607,674,2.23607,675,2.23607,676,2.23607,677,2.23607,678,2.23607,679,1,680,1,681,1,682,1,683,1,684,1,685,2.23607,686,2.23607,687,2.23607,688,2.23607,689,2.23607,690,2.23607,691,1,692,1,693,1,694,1,695,1,696,1,697,2.23607,698,2.23607,699,2.23607,700,2.23607,701,2.23607,702,2.23607,703,1,704,1,705,1,706,1,707,1,708,1,709,2.23607,710,2.23607,711,2.23607,712,2.23607,713,2.23607,714,2.23607,715,1,716,1,717,1,718,1,719,1,720,1,721,2.23607,722,2.23607,723,2.23607,724,2.23607,725,2.23607,726,2.23607,727,1,728,1,729,1,730,1,731,1,732,1,733,2.23607,734,2.23607,735,2.23607,736,2.23607,737,2.23607,738,2.23607,739,1,740,1,741,1,742,1,743,1,744,1,745,2.23607,746,2.23607,747,2.23607,748,2.23607,749,2.23607,750,2.23607,751,1,752,1,753,1,754,1,755,1,756,1,757,2.23607,758,2.23607,759,2.23607,760,2.23607,761,2.23607,762,2.23607,763,1,764,1,765,1,766,1,767,1,768,1,769,2.23607,770,2.23607,771,2.23607,772,2.23607,773,2.23607,774,2.23607,775,1,776,1,777,1,778,1,779,1,780,1,781,2.23607,782,2.23607,783,2.23607,784,2.23607,785,2.23607,786,2.23607,787,1,788,1,789,1,790,1,791,1,792,1,793,2.23607,794,2.23607,795,2.23607,796,2.23607,797,2.23607,798,2.23607,799,1,800,1,801,1,802,1,803,1,804,1,805,2.23607,806,2.23607,807,2.23607,808,2.23607,809,2.23607,810,2.23607,811,1,812,1,813,1,814,1,815,1,816,1,817,2.23607,818,2.23607,819,2.23607,820,2.23607,821,2.23607,822,2.23607,823,1,824,1,825,1,826,1,827,1,828,1,829,2.23607,830,2.23607,831,2.23607,832,2.23607,833,2.23607,834,2.23607,835,1,836,1,837,1,838,1,839,1,840,1,841,2.23607,842,2.23607,843,2.23607,844,2.23607,845,2.23607,846,2.23607,847,1,848,1,849,1,850,1,851,1,852,1,853,2.23607,854,2.23607,855,2.23607,856,2.23607,857,2.23607,858,2.23607,859,1,860,1,861,1,862,1,863,1,864,1,865,2.23607,866,2.23607,867,2.23607,868,2.23607,869,2.23607,870,2.23607,871,1,872,1,873,1,874,1,875,1,876,1,877,2.23607,878,2.23607,879,2.23607,880,2.23607,881,2.23607,882,2.23607,883,1,884,1,885,1,886,1,887,1,888,1,889,2.23607,890,2.23607,891,2.23607,892,2.23607,893,2.23607,894,2.23607,895,1,896,1,897,1,898,1,899,1,900,1,901,2.23607,902,2.23607,903,2.23607,904,2.23607,905,2.23607,906,2.23607,907,1,908,1,909,1,910,1,911,1,912,1,913,2.23607,914,2.23607,915,2.23607,916,2.23607,917,2.23607,918,2.23607,919,1,920,1,921,1,922,1,923,1,924,1,925,2.23607,926,2.23607,927,2.23607,928,2.23607,929,2.23607,930,2.23607,931,1,932,1,933,1,934,1,935,1,936,1,937,2.23607,938,2.23607,939,2.23607,940,2.23607,941,2.23607,942,2.23607,943,1,944,1,945,1,946,1,947,1,948,1,949,2.23607,950,2.23607,951,2.23607,952,2.23607,953,2.23607,954,2.23607,955,1,956,1,957,1,958,1,959,1,960,1,961,2.23607,962,2.23607,963,2.23607,964,2.23607,965,2.23607,966,2.23607,967,1,968,1,969,1,970,1,971,1,972,1,973,2.23607,974,2.23607,975,2.23607,976,2.23607,977,2.23607,978,2.23607,979,1,980,1,981,1,982,1,983,1,984,1,985,2.23607,986,2.23607,987,2.23607,988,2.23607,989,2.23607,990,2.23607,991,1,992,1,993,1,994,1,995,1,996,1,997,2.23607,998,2.23607,999,2.23607,1000,2.23607,1001,2.23607,1002,2.23607,1003,1,1004,1,1005,1,1006,1,1007,1,1008,1,1009,2.23607,1010,2.23607,1011,2.23607,1012,2.23607,1013,2.23607,1014,2.23607,1015,1,1016,1,1017,1,1018,1,1019,1,1020,1,1021,2.23607,1022,2.23607,1023,2.23607,1024,2.23607,1025,2.23607,1026,2.23607,1027,1,1028,1,1029,1,1030,1,1031,1,1032,1,1033,2.23607,1034,2.23607,1035,2.23607,1036,2.23607,1037,2.23607,1038,2.23607,1039,1,1040,1,1041,1,1042,1,1043,1,1044,1,1045,2.23607,1046,2.23607,1047,2.23607,1048,2.23607,1049,2.23607,1050,2.23607,1051,1,1052,1,1053,1,1054,1,1055,1,1056,1,1057,2.23607,1058,2.23607,1059,2.23607,1060,2.23607,1061,2.23607,1062,2.23607,1063,1,1064,1,1065,1,1066,1,1067,1,1068,1,1069,2.23607,1070,2.23607,1071,2.23607,1072,2.23607,1073,2.23607,1074,2.23607,1075,1,1076,1,1077,1,1078,1,1079,1,1080,1,1081,2.23607,1082,2.23607,1083,2.23607,1084,2.23607,1085,2.23607,1086,2.23607,1087,1,1088,1,1089,1,1090,1,1091,1,1092,1,1093,2.23607,1094,2.23607,1095,2.23607,1096,2.23607,1097,2.23607,1098,2.23607,1099,1,1100,1,1101,1,1102,1,1103,1,1104,1,1105,2.23607,1106,2.23607,1107,2.23607,1108,2.23607,1109,2.23607,1110,2.23607,1111,1,1112,1,1113,1,1114,1,1115,1,1116,1,1117,2.23607,1118,2.23607,1119,2.23607,1120,2.23607,1121,2.23607,1122,2.23607,1123,1,1124,1,1125,1,1126,1,1127,1,1128,1,1129,2.23607,1130,2.23607,1131,2.23607,1132,2.23607,1133,2.23607,1134,2.23607,1135,1,1136,1,1137,1,1138,1,1139,1,1140,1,1141,2.23607,1142,2.23607,1143,2.23607,1144,2.23607,1145,2.23607,1146,2.23607,1147,1,1148,1,1149,1,1150,1,1151,1,1152,1,1153,2.23607,1154,2.23607,1155,2.23607,1156,2.23607,1157,2.23607,1158,2.23607,1159,1,1160,1,1161,1,1162,1,1163,1,1164,1,1165,2.23607,1166,2.23607,1167,2.23607,1168,2.23607,1169,2.23607,1170,2.23607,1171,1,1172,1,1173,1,1174,1,1175,1,1176,1,1177,2.23607,1178,2.23607,1179,2.23607,1180,2.23607,1181,2.23607,1182,2.23607,1183,1,1184,1,1185,1,1186,1,1187,1,1188,1,1189,2.23607,1190,2.23607,1191,2.23607,1192,2.23607,1193,2.23607,1194,2.23607,1195,1,1196,1,1197,1,1198,1,1199,1,1200,1,1201,2.23607,1202,2.23607,1203,2.23607,1204,2.23607,1205,2.23607,1206,2.23607,1207,1,1208,1,1209,1,1210,1,1211,1,1212,1,1213,2.23607,1214,2.23607,1215,2.23607,1216,2.23607,1217,2.23607,1218,2.23607,1219,1,1220,1,1221,1,1222,1,1223,1,1224,1,1225,2.23607,1226,2.23607,1227,2.23607,1228,2.23607,1229,2.23607,1230,2.23607,1231,1,1232,1,1233,1,1234,1,1235,1,1236,1,1237,2.23607,1238,2.23607,1239,2.23607,1240,2.23607,1241,2.23607,1242,2.23607,1243,1,1244,1,1245,1,1246,1,1247,1,1248,1,1249,2.23607,1250,2.23607,1251,2.23607,1252,2.23607,1253,2.23607,1254,2.23607,1255,1,1256,1,1257,1,1258,1,1259,1,1260,1,1261,2.23607,1262,2.23607,1263,2.23607,1264,2.23607,1265,2.23607,1266,2.23607,1267,1,1268,1,1269,1,1270,1,1271,1,1272,1,1273,2.23607,1274,2.23607,1275,2.23607,1276,2.23607,1277,2.23607,1278,2.23607,1279,1,1280,1,1281,1,1282,1,1283,1,1284,1,1285,2.23607,1286,2.23607,1287,2.23607,1288,2.23607,1289,2.23607,1290,2.23607,1291,1,1292,1,1293,1,1294,1,1295,1,1296,1,1297,2.23607,1298,2.23607,1299,2.23607,1300,2.23607,1301,2.23607,1302,2.23607,1303,1,1304,1,1305,1,1306,1,1307,1,1308,1,1309,2.23607,1310,2.23607,1311,2.23607,1312,2.23607,1313,2.23607,1314,2.23607,1315,1,1316,1,1317,1,1318,1,1319,1,1320,1,1321,2.23607,1322,2.23607,1323,2.23607,1324,2.23607,1325,2.23607,1326,2.23607,1327,1,1328,1,1329,1,1330,1,1331,1,1332,1,1333,2.23607,1334,2.23607,1335,2.23607,1336,2.23607,1337,2.23607,1338,2.23607,1339,1,1340,1,1341,1,1342,1,1343,1,1344,1,1345,2.23607,1346,2.23607,1347,2.23607,1348,2.23607,1349,2.23607,1350,2.23607,1351,1,1352,1,1353,1,1354,1,1355,1,1356,1,1357,2.23607,1358,2.23607,1359,2.23607,1360,2.23607,1361,2.23607,1362,2.23607,1363,1,1364,1,1365,1,1366,1,1367,1,1368,1,1369,2.23607,1370,2.23607,1371,2.23607,1372,2.23607,1373,2.23607,1374,2.23607,1375,1,1376,1,1377,1,1378,1,1379,1,1380,1,1381,2.23607,1382,2.23607,1383,2.23607,1384,2.23607,1385,2.23607,1386,2.23607,1387,1,1388,1,1389,1,1390,1,1391,1,1392,1,1393,2.23607,1394,2.23607,1395,2.23607,1396,2.23607,1397,2.23607,1398,2.23607,1399,1,1400,1,1401,1,1402,1,1403,1,1404,1,1405,2.23607,1406,2.23607,1407,2.23607,1408,2.23607,1409,2.23607,1410,2.23607,1411,1,1412,1,1413,1,1414,1,1415,1,1416,1,1417,2.23607,1418,2.23607,1419,2.23607,1420,2.23607,1421,2.23607,1422,2.23607,1423,1,1424,1,1425,1,1426,1,1427,1,1428,1,1429,2.23607,1430,2.23607,1431,2.23607,1432,2.23607,1433,2.23607,1434,2.23607,1435,1,1436,1,1437,1,1438,1,1439,1,1440,1,1441,2.23607,1442,2.23607,1443,2.23607,1444,2.23607,1445,2.23607,1446,2.23607,1447,1,1448,1,1449,1,1450,1,1451,1,1452,1,1453,2.23607,1454,2.23607,1455,2.23607,1456,2.23607,1457,2.23607,1458,2.23607,1459,1,1460,1,1461,1,1462,1,1463,1,1464,1,1465,2.23607,1466,2.23607,1467,2.23607,1468,2.23607,1469,2.23607,1470,2.23607,1471,1,1472,1,1473,1,1474,1,1475,1,1476,1,1477,2.23607,1478,2.23607,1479,2.23607,1480,2.23607,1481,2.23607,1482,2.23607,1483,1,1484,1,1485,1,1486,1,1487,1,1488,1,1489,2.23607,1490,2.23607,1491,2.23607,1492,2.23607,1493,2.23607,1494,2.23607,1495,1,1496,1,1497,1,1498,1,1499,1,1500,1,1501,2.23607,1502,2.23607,1503,2.23607,1504,2.23607,1505,2.23607,1506,2.23607,1507,1,1508,1,1509,1,1510,1,1511,1,1512,1,1513,2.23607,1514,2.23607,1515,2.23607,1516,2.23607,1517,2.23607,1518,2.23607,1519,1,1520,1,1521,1,1522,1,1523,1,1524,1,1525,2.23607,1526,2.23607,1527,2.23607,1528,2.23607,1529,2.23607,1530,2.23607,1531,1,1532,1,1533,1,1534,1,1535,1,1536,1,1537,2.23607,1538,2.23607,1539,2.23607,1540,2.23607,1541,2.23607,1542,2.23607,1543,1,1544,1,1545,1,1546,1,1547,1,1548,1,1549,2.23607,1550,2.23607,1551,2.23607,1552,2.23607,1553,2.23607,1554,2.23607,1555,1,1556,1,1557,1,1558,1,1559,1,1560,1,1561,2.23607,1562,2.23607,1563,2.23607,1564,2.23607,1565,2.23607,1566,2.23607,1567,1,1568,1,1569,1,1570,1,1571,1,1572,1,1573,2.23607,1574,2.23607,1575,2.23607,1576,2.23607,1577,2.23607,1578,2.23607,1579,1,1580,1,1581,1,1582,1,1583,1,1584,1,1585,2.23607,1586,2.23607,1587,2.23607,1588,2.23607,1589,2.23607,1590,2.23607,1591,1,1592,1,1593,1,1594,1,1595,1,1596,1,1597,2.23607,1598,2.23607,1599,2.23607,1600,2.23607,1601,2.23607,1602,2.23607,1603,1,1604,1,1605,1,1606,1,1607,1,1608,1,1609,2.23607,1610,2.23607,1611,2.23607,1612,2.23607,1613,2.23607,1614,2.23607,1615,1,1616,1,1617,1,1618,1,1619,1,1620,1,1621,2.23607,1622,2.23607,1623,2.23607,1624,2.23607,1625,2.23607,1626,2.23607,1627,1,1628,1,1629,1,1630,1,1631,1,1632,1,1633,2.23607,1634,2.23607,1635,2.23607,1636,2.23607,1637,2.23607,1638,2.23607,1639,1,1640,1,1641,1,1642,1,1643,1,1644,1,1645,2.23607,1646,2.23607,1647,2.23607,1648,2.23607,1649,2.23607,1650,2.23607,1651,1,1652,1,1653,1,1654,1,1655,1,1656,1,1657,2.23607,1658,2.23607,1659,2.23607,1660,2.23607,1661,2.23607,1662,2.23607,1663,1,1664,1,1665,1,1666,1,1667,1,1668,1,1669,2.23607,1670,2.23607,1671,2.23607,1672,2.23607,1673,2.23607,1674,2.23607,1675,1,1676,1,1677,1,1678,1,1679,1,1680,1,1681,2.23607,1682,2.23607,1683,2.23607,1684,2.23607,1685,2.23607,1686,2.23607,1687,1,1688,1,1689,1,1690,1,1691,1,1692,1,1693,2.23607,1694,2.23607,1695,2.23607,1696,2.23607,1697,2.23607,1698,2.23607,1699,1,1700,1,1701,1,1702,1,1703,1,1704,1,1705,2.23607,1706,2.23607,1707,2.23607,1708,2.23607,1709,2.23607,1710,2.23607,1711,1,1712,1,1713,1,1714,1,1715,1,1716,1,1717,2.23607,1718,2.23607,1719,2.23607,1720,2.23607,1721,2.23607,1722,2.23607,1723,1,1724,1,1725,1,1726,1,1727,1,1728,1,1729,2.23607,1730,2.23607,1731,2.23607,1732,2.23607,1733,2.23607,1734,2.23607,1735,1,1736,1,1737,1,1738,1,1739,1,1740,1,1741,2.23607,1742,2.23607,1743,2.23607,1744,2.23607,1745,2.23607,1746,2.23607,1747,1,1748,1,1749,1,1750,1,1751,1,1752,1,1753,2.23607,1754,2.23607,1755,2.23607,1756,2.23607,1757,2.23607,1758,2.23607,1759,1,1760,1,1761,1,1762,1,1763,1,1764,1,1765,2.23607,1766,2.23607,1767,2.23607,1768,2.23607,1769,2.23607,1770,2.23607,1771,1,1772,1,1773,1,1774,1,1775,1,1776,1,1777,2.23607,1778,2.23607,1779,2.23607,1780,2.23607,1781,2.23607,1782,2.23607,1783,1,1784,1,1785,1,1786,1,1787,1,1788,1,1789,2.23607,1790,2.23607,1791,2.23607,1792,2.23607,1793,2.23607,1794,2.23607,1795,1,1796,1,1797,1,1798,1,1799,1,1800,1,1801,2.23607,1802,2.23607,1803,2.23607,1804,2.23607,1805,2.23607,1806,2.23607,1807,1,1808,1,1809,1,1810,1,1811,1,1812,1,1813,2.23607,1814,2.23607,1815,2.23607,1816,2.23607,1817,2.23607,1818,2.23607,1819,1,1820,1,1821,1,1822,1,1823,1,1824,1,1825,2.23607,1826,2.23607,1827,2.23607,1828,2.23607,1829,2.23607,1830,2.23607,1831,1,1832,1,1833,1,1834,1,1835,1,1836,1,1837,2.23607,1838,2.23607,1839,2.23607,1840,2.23607,1841,2.23607,1842,2.23607,1843,1,1844,1,1845,1,1846,1,1847,1,1848,1,1849,2.23607,1850,2.23607,1851,2.23607,1852,2.23607,1853,2.23607,1854,2.23607,1855,1,1856,1,1857,1,1858,1,1859,1,1860,1,1861,2.23607,1862,2.23607,1863,2.23607,1864,2.23607,1865,2.23607,1866,2.23607,1867,1,1868,1,1869,1,1870,1,1871,1,1872,1,1873,2.23607,1874,2.23607,1875,2.23607,1876,2.23607,1877,2.23607,1878,2.23607,1879,1,1880,1,1881,1,1882,1,1883,1,1884,1,1885,2.23607,1886,2.23607,1887,2.23607,1888,2.23607,1889,2.23607,1890,2.23607,1891,1,1892,1,1893,1,1894,1,1895,1,1896,1,1897,2.23607,1898,2.23607,1899,2.23607,1900,2.23607,1901,2.23607,1902,2.23607,1903,1,1904,1,1905,1,1906,1,1907,1,1908,1,1909,2.23607,1910,2.23607,1911,2.23607,1912,2.23607,1913,2.23607,1914,2.23607,1915,1,1916,1,1917,1,1918,1,1919,1,1920,1,1921,2.23607,1922,2.23607,1923,2.23607,1924,2.23607,1925,2.23607,1926,2.23607,1927,1,1928,1,1929,1,1930,1,1931,1,1932,1,1933,2.23607,1934,2.23607,1935,2.23607,1936,2.23607,1937,2.23607,1938,2.23607,1939,1,1940,1,1941,1,1942,1,1943,1,1944,1,1945,2.23607,1946,2.23607,1947,2.23607,1948,2.23607,1949,2.23607,1950,2.23607,1951,1,1952,1,1953,1,1954,1,1955,1,1956,1,1957,2.23607,1958,2.23607,1959,2.23607,1960,2.23607,1961,2.23607,1962,2.23607,1963,1,1964,1,1965,1,1966,1,1967,1,1968,1,1969,2.23607,1970,2.23607,1971,2.23607,1972,2.23607,1973,2.23607,1974,2.23607,1975,1,1976,1,1977,1,1978,1,1979,1,1980,1,1981,2.23607,1982,2.23607,1983,2.23607,1984,2.23607,1985,2.23607,1986,2.23607,1987,1,1988,1,1989,1,1990,1,1991,1,1992,1,1993,2.23607,1994,2.23607,1995,2.23607,1996,2.23607,1997,2.23607,1998,2.23607,1999,1,2000,1,2001,1,2002,1,2003,1,2004,1,2005,2.23607,2006,2.23607,2007,2.23607,2008,2.23607,2009,2.23607,2010,2.23607,2011,1,2012,1,2013,1,2014,1,2015,1,2016,1,2017,2.23607,2018,2.23607,2019,2.23607,2020,2.23607,2021,2.23607,2022,2.23607,2023,1,2024,1,2025,1,2026,1,2027,1,2028,1,2029,2.23607,2030,2.23607,2031,2.23607,2032,2.23607,2033,2.23607,2034,2.23607,2035,1,2036,1,2037,1,2038,1,2039,1,2040,1,2041,2.23607,2042,2.23607,2043,2.23607,2044,2.23607,2045,2.23607,2046,2.23607,2047,1,2048,1,2049,1,2050,1,2051,1,2052,1,2053,2.23607,2054,2.23607,2055,2.23607,2056,2.23607,2057,2.23607,2058,2.23607,2059,1,2060,1,2061,1,2062,1,2063,1,2064,1,2065,2.23607,2066,2.23607,2067,2.23607,2068,2.23607,2069,2.23607,2070,2.23607,2071,1,2072,1,2073,1,2074,1,2075,1,2076,1,2077,2.23607,2078,2.23607,2079,2.23607,2080,2.23607,2081,2.23607,2082,2.23607,2083,1,2084,1,2085,1,2086,1,2087,1,2088,1,2089,2.23607,2090,2.23607,2091,2.23607,2092,2.23607,2093,2.23607,2094,2.23607,2095,1,2096,1,2097,1,2098,1,2099,1,2100,1,2101,2.23607,2102,2.23607,2103,2.23607,2104,2.23607,2105,2.23607,2106,2.23607,2107,1,2108,1,2109,1,2110,1,2111,1,2112,1,2113,2.23607,2114,2.23607,2115,2.23607,2116,2.23607,2117,2.23607,2118,2.23607,2119,1,2120,1,2121,1,2122,1,2123,1,2124,1,2125,2.23607,2126,2.23607,2127,2.23607,2128,2.23607,2129,2.23607,2130,2.23607,2131,1,2132,1,2133,1,2134,1,2135,1,2136,1,2137,2.23607,2138,2.23607,2139,2.23607,2140,2.23607,2141,2.23607,2142,2.23607,2143,1,2144,1,2145,1,2146,1,2147,1,2148,1,2149,2.23607,2150,2.23607,2151,2.23607,2152,2.23607,2153,2.23607,2154,2.23607,2155,1,2156,1,2157,1,2158,1,2159,1,2160,1,2161,2.23607,2162,2.23607,2163,2.23607,2164,2.23607,2165,2.23607,2166,2.23607,2167,1,2168,1,2169,1,2170,1,2171,1,2172,1,2173,2.23607,2174,2.23607,2175,2.23607,2176,2.23607,2177,2.23607,2178,2.23607,2179,1,2180,1,2181,1,2182,1,2183,1,2184,1,2185,2.23607,2186,2.23607,2187,2.23607,2188,2.23607,2189,2.23607,2190,2.23607,2191,1,2192,1,2193,1,2194,1,2195,1,2196,1,2197,2.23607,2198,2.23607,2199,2.23607,2200,2.23607,2201,2.23607,2202,2.23607,2203,1,2204,1,2205,1,2206,1,2207,1,2208,1,2209,2.23607,2210,2.23607,2211,2.23607,2212,2.23607,2213,2.23607,2214,2.23607,2215,1,2216,1,2217,1,2218,1,2219,1,2220,1,2221,2.23607,2222,2.23607,2223,2.23607,2224,2.23607,2225,2.23607,2226,2.23607,2227,1,2228,1,2229,1,2230,1,2231,1,2232,1,2233,2.23607,2234,2.23607,2235,2.23607,2236,2.23607,2237,2.23607,2238,2.23607,2239,1,2240,1,2241,1,2242,1,2243,1,2244,1,2245,2.23607,2246,2.23607,2247,2.23607,2248,2.23607,2249,2.23607,2250,2.23607,2251,1,2252,1,2253,1,2254,1,2255,1,2256,1,2257,2.23607,2258,2.23607,2259,2.23607,2260,2.23607,2261,2.23607,2262,2.23607,2263,1,2264,1,2265,1,2266,1,2267,1,2268,1,2269,2.23607,2270,2.23607,2271,2.23607,2272,2.23607,2273,2.23607,2274,2.23607,2275,1,2276,1,2277,1,2278,1,2279,1,2280,1,2281,2.23607,2282,2.23607,2283,2.23607,2284,2.23607,2285,2.23607,2286,2.23607,2287,1,2288,1,2289,1,2290,1,2291,1,2292,1,2293,2.23607,2294,2.23607,2295,2.23607,2296,2.23607,2297,2.23607,2298,2.23607,2299,1,2300,1,2301,1,2302,1,2303,1,2304,1,2305,2.23607,2306,2.23607,2307,2.23607,2308,2.23607,2309,2.23607,2310,2.23607,2311,1,2312,1,2313,1,2314,1,2315,1,2316,1,2317,2.23607,2318,2.23607,2319,2.23607,2320,2.23607,2321,2.23607,2322,2.23607,2323,1,2324,1,2325,1,2326,1,2327,1,2328,1,2329,2.23607,2330,2.23607,2331,2.23607,2332,2.23607,2333,2.23607,2334,2.23607,2335,1,2336,1,2337,1,2338,1,2339,1,2340,1,2341,2.23607,2342,2.23607,2343,2.23607,2344,2.23607,2345,2.23607,2346,2.23607,2347,1,2348,1,2349,1,2350,1,2351,1,2352,1,2353,2.23607,2354,2.23607,2355,2.23607,2356,2.23607,2357,2.23607,2358,2.23607,2359,1,2360,1,2361,1,2362,1,2363,1,2364,1,2365,2.23607,2366,2.23607,2367,2.23607,2368,2.23607,2369,2.23607,2370,2.23607,2371,1,2372,1,2373,1,2374,1,2375,1,2376,1,2377,2.23607,2378,2.23607,2379,2.23607,2380,2.23607,2381,2.23607,2382,2.23607,2383,1,2384,1,2385,1,2386,1,2387,1,2388,1,2389,2.23607,2390,2.23607,2391,2.23607,2392,2.23607,2393,2.23607,2394,2.23607,2395,1,2396,1,2397,1,2398,1,2399,1,2400,1,2401,2.23607,2402,2.23607,2403,2.23607,2404,2.23607,2405,2.23607,2406,2.23607,2407,1,2408,1,2409,1,2410,1,2411,1,2412,1,2413,2.23607,2414,2.23607,2415,2.23607,2416,2.23607,2417,2.23607,2418,2.23607,2419,1,2420,1,2421,1,2422,1,2423,1,2424,1,2425,2.23607,2426,2.23607,2427,2.23607,2428,2.23607,2429,2.23607,2430,2.23607,2431,1,2432,1,2433,1,2434,1,2435,1,2436,1,2437,2.23607,2438,2.23607,2439,2.23607,2440,2.23607,2441,2.23607,2442,2.23607,2443,1,2444,1,2445,1,2446,1,2447,1,2448,1,2449,2.23607,2450,2.23607,2451,2.23607,2452,2.23607,2453,2.23607,2454,2.23607,2455,1,2456,1,2457,1,2458,1,2459,1,2460,1,2461,2.23607,2462,2.23607,2463,2.23607,2464,2.23607,2465,2.23607,2466,2.23607,2467,1,2468,1,2469,1,2470,1,2471,1,2472,1,2473,2.23607,2474,2.23607,2475,2.23607,2476,2.23607,2477,2.23607,2478,2.23607,2479,1,2480,1,2481,1,2482,1,2483,1,2484,1,2485,2.23607,2486,2.23607,2487,2.23607,2488,2.23607,2489,2.23607,2490,2.23607,2491,1,2492,1,2493,1,2494,1,2495,1,2496,1,2497,2.23607,2498,2.23607,2499,2.23607,2500,2.23607,2501,2.23607,2502,2.23607,2503,1,2504,1,2505,1,2506,1,2507,1,2508,1,2509,2.23607,2510,2.23607,2511,2.23607,2512,2.23607,2513,2.23607,2514,2.23607,2515,1,2516,1,2517,1,2518,1,2519,1,2520,1,2521,2.23607,2522,2.23607,2523,2.23607,2524,2.23607,2525,2.23607,2526,2.23607,2527,1,2528,1,2529,1,2530,1,2531,1,2532,1,2533,2.23607,2534,2.23607,2535,2.23607,2536,2.23607,2537,2.23607,2538,2.23607,2539,1,2540,1,2541,1,2542,1,2543,1,2544,1,2545,2.23607,2546,2.23607,2547,2.23607,2548,2.23607,2549,2.23607,2550,2.23607,2551,1,2552,1,2553,1,2554,1,2555,1,2556,1,2557,2.23607,2558,2.23607,2559,2.23607,2560,2.23607,2561,2.23607,2562,2.23607,2563,1,2564,1,2565,1,2566,1,2567,1,2568,1,2569,2.23607,2570,2.23607,2571,2.23607,2572,2.23607,2573,2.23607,2574,2.23607,2575,1,2576,1,2577,1,2578,1,2579,1,2580,1,2581,2.23607,2582,2.23607,2583,2.23607,2584,2.23607,2585,2.23607,2586,2.23607,2587,1,2588,1,2589,1,2590,1,2591,1,2592,1,2593,2.23607,2594,2.23607,2595,2.23607,2596,2.23607,2597,2.23607,2598,2.23607,2599,1,2600,1,2601,1,2602,1,2603,1,2604,1)
.param SUB=table(run,1,100,2,100,3,100,4,100,5,100,6,100,7,100,8,100,9,100,10,100,11,100,12,100,13,100,14,100,15,100,16,100,17,100,18,100,19,100,20,100,21,100,22,100,23,100,24,100,25,100,26,100,27,100,28,100,29,100,30,100,31,100,32,100,33,100,34,100,35,100,36,100,37,100,38,100,39,100,40,100,41,100,42,100,43,100,44,100,45,100,46,100,47,100,48,100,49,100,50,100,51,100,52,100,53,100,54,100,55,100,56,100,57,100,58,100,59,100,60,100,61,100,62,100,63,100,64,100,65,100,66,100,67,100,68,100,69,100,70,100,71,100,72,100,73,100,74,100,75,100,76,100,77,100,78,100,79,100,80,100,81,100,82,100,83,100,84,100,85,100,86,100,87,100,88,100,89,100,90,100,91,100,92,100,93,100,94,100,95,100,96,100,97,100,98,100,99,100,100,100,101,100,102,100,103,100,104,100,105,100,106,100,107,100,108,100,109,100,110,100,111,100,112,100,113,100,114,100,115,100,116,100,117,100,118,100,119,100,120,100,121,100,122,100,123,100,124,100,125,100,126,100,127,100,128,100,129,100,130,100,131,100,132,100,133,100,134,100,135,100,136,100,137,100,138,100,139,100,140,100,141,100,142,100,143,100,144,100,145,100,146,100,147,100,148,100,149,100,150,100,151,100,152,100,153,100,154,100,155,100,156,100,157,100,158,100,159,100,160,100,161,100,162,100,163,100,164,100,165,100,166,100,167,100,168,100,169,100,170,100,171,100,172,100,173,100,174,100,175,100,176,100,177,100,178,100,179,100,180,100,181,100,182,100,183,100,184,100,185,100,186,100,187,100,188,100,189,100,190,100,191,100,192,100,193,100,194,100,195,100,196,100,197,100,198,100,199,100,200,100,201,100,202,100,203,100,204,100,205,100,206,100,207,100,208,100,209,100,210,100,211,100,212,100,213,100,214,100,215,100,216,100,217,100,218,100,219,100,220,100,221,100,222,100,223,100,224,100,225,100,226,100,227,100,228,100,229,100,230,100,231,100,232,100,233,100,234,100,235,100,236,100,237,100,238,100,239,100,240,100,241,100,242,100,243,100,244,100,245,100,246,100,247,100,248,100,249,100,250,100,251,100,252,100,253,100,254,100,255,100,256,100,257,100,258,100,259,100,260,100,261,100,262,100,263,100,264,100,265,100,266,100,267,100,268,100,269,100,270,100,271,100,272,100,273,100,274,100,275,100,276,100,277,100,278,100,279,100,280,100,281,100,282,100,283,100,284,100,285,100,286,100,287,100,288,100,289,100,290,100,291,100,292,100,293,100,294,100,295,100,296,100,297,100,298,100,299,100,300,100,301,100,302,100,303,100,304,100,305,100,306,100,307,100,308,100,309,100,310,100,311,100,312,100,313,100,314,100,315,100,316,100,317,100,318,100,319,100,320,100,321,100,322,100,323,100,324,100,325,100,326,100,327,100,328,100,329,100,330,100,331,100,332,100,333,100,334,100,335,100,336,100,337,100,338,100,339,100,340,100,341,100,342,100,343,100,344,100,345,100,346,100,347,100,348,100,349,100,350,100,351,100,352,100,353,100,354,100,355,100,356,100,357,100,358,100,359,100,360,100,361,100,362,100,363,100,364,100,365,100,366,100,367,100,368,100,369,100,370,100,371,100,372,100,373,100,374,100,375,100,376,100,377,100,378,100,379,100,380,100,381,100,382,100,383,100,384,100,385,100,386,100,387,100,388,100,389,100,390,100,391,100,392,100,393,100,394,100,395,100,396,100,397,100,398,100,399,100,400,100,401,100,402,100,403,100,404,100,405,100,406,100,407,100,408,100,409,100,410,100,411,100,412,100,413,100,414,100,415,100,416,100,417,100,418,100,419,100,420,100,421,100,422,100,423,100,424,100,425,100,426,100,427,100,428,100,429,100,430,100,431,100,432,100,433,100,434,100,435,100,436,100,437,100,438,100,439,100,440,100,441,100,442,100,443,100,444,100,445,100,446,100,447,100,448,100,449,100,450,100,451,100,452,100,453,100,454,100,455,100,456,100,457,100,458,100,459,100,460,100,461,100,462,100,463,100,464,100,465,100,466,100,467,100,468,100,469,100,470,100,471,100,472,100,473,100,474,100,475,100,476,100,477,100,478,100,479,100,480,100,481,100,482,100,483,100,484,100,485,100,486,100,487,100,488,100,489,100,490,100,491,100,492,100,493,100,494,100,495,100,496,100,497,100,498,100,499,100,500,100,501,100,502,100,503,100,504,100,505,100,506,100,507,100,508,100,509,100,510,100,511,100,512,100,513,100,514,100,515,100,516,100,517,100,518,100,519,100,520,100,521,100,522,100,523,100,524,100,525,100,526,100,527,100,528,100,529,100,530,100,531,100,532,100,533,100,534,100,535,100,536,100,537,100,538,100,539,100,540,100,541,100,542,100,543,100,544,100,545,100,546,100,547,100,548,100,549,100,550,100,551,100,552,100,553,100,554,100,555,100,556,100,557,100,558,100,559,100,560,100,561,100,562,100,563,100,564,100,565,100,566,100,567,100,568,100,569,100,570,100,571,100,572,100,573,100,574,100,575,100,576,100,577,100,578,100,579,100,580,100,581,100,582,100,583,100,584,100,585,100,586,100,587,100,588,100,589,100,590,100,591,100,592,100,593,100,594,100,595,100,596,100,597,100,598,100,599,100,600,100,601,100,602,100,603,100,604,100,605,100,606,100,607,100,608,100,609,100,610,100,611,100,612,100,613,100,614,100,615,100,616,100,617,100,618,100,619,100,620,100,621,100,622,100,623,100,624,100,625,100,626,100,627,100,628,100,629,100,630,100,631,100,632,100,633,100,634,100,635,100,636,100,637,100,638,100,639,100,640,100,641,100,642,100,643,100,644,100,645,100,646,100,647,100,648,100,649,100,650,100,651,100,652,100,653,100,654,100,655,100,656,100,657,100,658,100,659,100,660,100,661,100,662,100,663,100,664,100,665,100,666,100,667,100,668,100,669,100,670,100,671,100,672,100,673,100,674,100,675,100,676,100,677,100,678,100,679,100,680,100,681,100,682,100,683,100,684,100,685,100,686,100,687,100,688,100,689,100,690,100,691,100,692,100,693,100,694,100,695,100,696,100,697,100,698,100,699,100,700,100,701,100,702,100,703,100,704,100,705,100,706,100,707,100,708,100,709,100,710,100,711,100,712,100,713,100,714,100,715,100,716,100,717,100,718,100,719,100,720,100,721,100,722,100,723,100,724,100,725,100,726,100,727,100,728,100,729,100,730,100,731,100,732,100,733,100,734,100,735,100,736,100,737,100,738,100,739,100,740,100,741,100,742,100,743,100,744,100,745,100,746,100,747,100,748,100,749,100,750,100,751,100,752,100,753,100,754,100,755,100,756,100,757,100,758,100,759,100,760,100,761,100,762,100,763,100,764,100,765,100,766,100,767,100,768,100,769,100,770,100,771,100,772,100,773,100,774,100,775,100,776,100,777,100,778,100,779,100,780,100,781,100,782,100,783,100,784,100,785,100,786,100,787,100,788,100,789,100,790,100,791,100,792,100,793,100,794,100,795,100,796,100,797,100,798,100,799,100,800,100,801,100,802,100,803,100,804,100,805,100,806,100,807,100,808,100,809,100,810,100,811,100,812,100,813,100,814,100,815,100,816,100,817,100,818,100,819,100,820,100,821,100,822,100,823,100,824,100,825,100,826,100,827,100,828,100,829,100,830,100,831,100,832,100,833,100,834,100,835,100,836,100,837,100,838,100,839,100,840,100,841,100,842,100,843,100,844,100,845,100,846,100,847,100,848,100,849,100,850,100,851,100,852,100,853,100,854,100,855,100,856,100,857,100,858,100,859,100,860,100,861,100,862,100,863,100,864,100,865,100,866,100,867,100,868,100,869,100,870,100,871,100,872,100,873,100,874,100,875,100,876,100,877,100,878,100,879,100,880,100,881,100,882,100,883,100,884,100,885,100,886,100,887,100,888,100,889,100,890,100,891,100,892,100,893,100,894,100,895,100,896,100,897,100,898,100,899,100,900,100,901,100,902,100,903,100,904,100,905,100,906,100,907,100,908,100,909,100,910,100,911,100,912,100,913,100,914,100,915,100,916,100,917,100,918,100,919,100,920,100,921,100,922,100,923,100,924,100,925,100,926,100,927,100,928,100,929,100,930,100,931,100,932,100,933,100,934,100,935,100,936,100,937,100,938,100,939,100,940,100,941,100,942,100,943,100,944,100,945,100,946,100,947,100,948,100,949,100,950,100,951,100,952,100,953,100,954,100,955,100,956,100,957,100,958,100,959,100,960,100,961,100,962,100,963,100,964,100,965,100,966,100,967,100,968,100,969,100,970,100,971,100,972,100,973,100,974,100,975,100,976,100,977,100,978,100,979,100,980,100,981,100,982,100,983,100,984,100,985,100,986,100,987,100,988,100,989,100,990,100,991,100,992,100,993,100,994,100,995,100,996,100,997,100,998,100,999,100,1000,100,1001,100,1002,100,1003,100,1004,100,1005,100,1006,100,1007,100,1008,100,1009,100,1010,100,1011,100,1012,100,1013,100,1014,100,1015,100,1016,100,1017,100,1018,100,1019,100,1020,100,1021,100,1022,100,1023,100,1024,100,1025,100,1026,100,1027,100,1028,100,1029,100,1030,100,1031,100,1032,100,1033,100,1034,100,1035,100,1036,100,1037,100,1038,100,1039,100,1040,100,1041,100,1042,100,1043,100,1044,100,1045,100,1046,100,1047,100,1048,100,1049,100,1050,100,1051,100,1052,100,1053,100,1054,100,1055,100,1056,100,1057,100,1058,100,1059,100,1060,100,1061,100,1062,100,1063,100,1064,100,1065,100,1066,100,1067,100,1068,100,1069,100,1070,100,1071,100,1072,100,1073,100,1074,100,1075,100,1076,100,1077,100,1078,100,1079,100,1080,100,1081,100,1082,100,1083,100,1084,100,1085,100,1086,100,1087,100,1088,100,1089,100,1090,100,1091,100,1092,100,1093,100,1094,100,1095,100,1096,100,1097,100,1098,100,1099,100,1100,100,1101,100,1102,100,1103,100,1104,100,1105,100,1106,100,1107,100,1108,100,1109,100,1110,100,1111,100,1112,100,1113,100,1114,100,1115,100,1116,100,1117,100,1118,100,1119,100,1120,100,1121,100,1122,100,1123,100,1124,100,1125,100,1126,100,1127,100,1128,100,1129,100,1130,100,1131,100,1132,100,1133,100,1134,100,1135,100,1136,100,1137,100,1138,100,1139,100,1140,100,1141,100,1142,100,1143,100,1144,100,1145,100,1146,100,1147,100,1148,100,1149,100,1150,100,1151,100,1152,100,1153,100,1154,100,1155,100,1156,100,1157,100,1158,100,1159,100,1160,100,1161,100,1162,100,1163,100,1164,100,1165,100,1166,100,1167,100,1168,100,1169,100,1170,100,1171,100,1172,100,1173,100,1174,100,1175,100,1176,100,1177,100,1178,100,1179,100,1180,100,1181,100,1182,100,1183,100,1184,100,1185,100,1186,100,1187,100,1188,100,1189,100,1190,100,1191,100,1192,100,1193,100,1194,100,1195,100,1196,100,1197,100,1198,100,1199,100,1200,100,1201,100,1202,100,1203,100,1204,100,1205,100,1206,100,1207,100,1208,100,1209,100,1210,100,1211,100,1212,100,1213,100,1214,100,1215,100,1216,100,1217,100,1218,100,1219,100,1220,100,1221,100,1222,100,1223,100,1224,100,1225,100,1226,100,1227,100,1228,100,1229,100,1230,100,1231,100,1232,100,1233,100,1234,100,1235,100,1236,100,1237,100,1238,100,1239,100,1240,100,1241,100,1242,100,1243,100,1244,100,1245,100,1246,100,1247,100,1248,100,1249,100,1250,100,1251,100,1252,100,1253,100,1254,100,1255,100,1256,100,1257,100,1258,100,1259,100,1260,100,1261,100,1262,100,1263,100,1264,100,1265,100,1266,100,1267,100,1268,100,1269,100,1270,100,1271,100,1272,100,1273,100,1274,100,1275,100,1276,100,1277,100,1278,100,1279,100,1280,100,1281,100,1282,100,1283,100,1284,100,1285,100,1286,100,1287,100,1288,100,1289,100,1290,100,1291,100,1292,100,1293,100,1294,100,1295,100,1296,100,1297,100,1298,100,1299,100,1300,100,1301,100,1302,100,1303,100,1304,100,1305,100,1306,100,1307,100,1308,100,1309,100,1310,100,1311,100,1312,100,1313,100,1314,100,1315,100,1316,100,1317,100,1318,100,1319,100,1320,100,1321,100,1322,100,1323,100,1324,100,1325,100,1326,100,1327,100,1328,100,1329,100,1330,100,1331,100,1332,100,1333,100,1334,100,1335,100,1336,100,1337,100,1338,100,1339,100,1340,100,1341,100,1342,100,1343,100,1344,100,1345,100,1346,100,1347,100,1348,100,1349,100,1350,100,1351,100,1352,100,1353,100,1354,100,1355,100,1356,100,1357,100,1358,100,1359,100,1360,100,1361,100,1362,100,1363,100,1364,100,1365,100,1366,100,1367,100,1368,100,1369,100,1370,100,1371,100,1372,100,1373,100,1374,100,1375,100,1376,100,1377,100,1378,100,1379,100,1380,100,1381,100,1382,100,1383,100,1384,100,1385,100,1386,100,1387,100,1388,100,1389,100,1390,100,1391,100,1392,100,1393,100,1394,100,1395,100,1396,100,1397,100,1398,100,1399,100,1400,100,1401,100,1402,100,1403,100,1404,100,1405,100,1406,100,1407,100,1408,100,1409,100,1410,100,1411,100,1412,100,1413,100,1414,100,1415,100,1416,100,1417,100,1418,100,1419,100,1420,100,1421,100,1422,100,1423,100,1424,100,1425,100,1426,100,1427,100,1428,100,1429,100,1430,100,1431,100,1432,100,1433,100,1434,100,1435,100,1436,100,1437,100,1438,100,1439,100,1440,100,1441,100,1442,100,1443,100,1444,100,1445,100,1446,100,1447,100,1448,100,1449,100,1450,100,1451,100,1452,100,1453,100,1454,100,1455,100,1456,100,1457,100,1458,100,1459,100,1460,100,1461,100,1462,100,1463,100,1464,100,1465,100,1466,100,1467,100,1468,100,1469,100,1470,100,1471,100,1472,100,1473,100,1474,100,1475,100,1476,100,1477,100,1478,100,1479,100,1480,100,1481,100,1482,100,1483,100,1484,100,1485,100,1486,100,1487,100,1488,100,1489,100,1490,100,1491,100,1492,100,1493,100,1494,100,1495,100,1496,100,1497,100,1498,100,1499,100,1500,100,1501,100,1502,100,1503,100,1504,100,1505,100,1506,100,1507,100,1508,100,1509,100,1510,100,1511,100,1512,100,1513,100,1514,100,1515,100,1516,100,1517,100,1518,100,1519,100,1520,100,1521,100,1522,100,1523,100,1524,100,1525,100,1526,100,1527,100,1528,100,1529,100,1530,100,1531,100,1532,100,1533,100,1534,100,1535,100,1536,100,1537,100,1538,100,1539,100,1540,100,1541,100,1542,100,1543,100,1544,100,1545,100,1546,100,1547,100,1548,100,1549,100,1550,100,1551,100,1552,100,1553,100,1554,100,1555,100,1556,100,1557,100,1558,100,1559,100,1560,100,1561,100,1562,100,1563,100,1564,100,1565,100,1566,100,1567,100,1568,100,1569,100,1570,100,1571,100,1572,100,1573,100,1574,100,1575,100,1576,100,1577,100,1578,100,1579,100,1580,100,1581,100,1582,100,1583,100,1584,100,1585,100,1586,100,1587,100,1588,100,1589,100,1590,100,1591,100,1592,100,1593,100,1594,100,1595,100,1596,100,1597,100,1598,100,1599,100,1600,100,1601,100,1602,100,1603,100,1604,100,1605,100,1606,100,1607,100,1608,100,1609,100,1610,100,1611,100,1612,100,1613,100,1614,100,1615,100,1616,100,1617,100,1618,100,1619,100,1620,100,1621,100,1622,100,1623,100,1624,100,1625,100,1626,100,1627,100,1628,100,1629,100,1630,100,1631,100,1632,100,1633,100,1634,100,1635,100,1636,100,1637,100,1638,100,1639,100,1640,100,1641,100,1642,100,1643,100,1644,100,1645,100,1646,100,1647,100,1648,100,1649,100,1650,100,1651,100,1652,100,1653,100,1654,100,1655,100,1656,100,1657,100,1658,100,1659,100,1660,100,1661,100,1662,100,1663,100,1664,100,1665,100,1666,100,1667,100,1668,100,1669,100,1670,100,1671,100,1672,100,1673,100,1674,100,1675,100,1676,100,1677,100,1678,100,1679,100,1680,100,1681,100,1682,100,1683,100,1684,100,1685,100,1686,100,1687,100,1688,100,1689,100,1690,100,1691,100,1692,100,1693,100,1694,100,1695,100,1696,100,1697,100,1698,100,1699,100,1700,100,1701,100,1702,100,1703,100,1704,100,1705,100,1706,100,1707,100,1708,100,1709,100,1710,100,1711,100,1712,100,1713,100,1714,100,1715,100,1716,100,1717,100,1718,100,1719,100,1720,100,1721,100,1722,100,1723,100,1724,100,1725,100,1726,100,1727,100,1728,100,1729,100,1730,100,1731,100,1732,100,1733,100,1734,100,1735,100,1736,100,1737,100,1738,100,1739,100,1740,100,1741,100,1742,100,1743,100,1744,100,1745,100,1746,100,1747,100,1748,100,1749,100,1750,100,1751,100,1752,100,1753,100,1754,100,1755,100,1756,100,1757,100,1758,100,1759,100,1760,100,1761,100,1762,100,1763,100,1764,100,1765,100,1766,100,1767,100,1768,100,1769,100,1770,100,1771,100,1772,100,1773,100,1774,100,1775,100,1776,100,1777,100,1778,100,1779,100,1780,100,1781,100,1782,100,1783,100,1784,100,1785,100,1786,100,1787,100,1788,100,1789,100,1790,100,1791,100,1792,100,1793,100,1794,100,1795,100,1796,100,1797,100,1798,100,1799,100,1800,100,1801,100,1802,100,1803,100,1804,100,1805,100,1806,100,1807,100,1808,100,1809,100,1810,100,1811,100,1812,100,1813,100,1814,100,1815,100,1816,100,1817,100,1818,100,1819,100,1820,100,1821,100,1822,100,1823,100,1824,100,1825,100,1826,100,1827,100,1828,100,1829,100,1830,100,1831,100,1832,100,1833,100,1834,100,1835,100,1836,100,1837,100,1838,100,1839,100,1840,100,1841,100,1842,100,1843,100,1844,100,1845,100,1846,100,1847,100,1848,100,1849,100,1850,100,1851,100,1852,100,1853,100,1854,100,1855,100,1856,100,1857,100,1858,100,1859,100,1860,100,1861,65,1862,65,1863,65,1864,65,1865,65,1866,65,1867,65,1868,65,1869,65,1870,65,1871,65,1872,65,1873,65,1874,65,1875,65,1876,65,1877,65,1878,65,1879,65,1880,65,1881,65,1882,65,1883,65,1884,65,1885,65,1886,65,1887,65,1888,65,1889,65,1890,65,1891,65,1892,65,1893,65,1894,65,1895,65,1896,65,1897,65,1898,65,1899,65,1900,65,1901,65,1902,65,1903,65,1904,65,1905,65,1906,65,1907,65,1908,65,1909,65,1910,65,1911,65,1912,65,1913,65,1914,65,1915,65,1916,65,1917,65,1918,65,1919,65,1920,65,1921,65,1922,65,1923,65,1924,65,1925,65,1926,65,1927,65,1928,65,1929,65,1930,65,1931,65,1932,65,1933,65,1934,65,1935,65,1936,65,1937,65,1938,65,1939,65,1940,65,1941,65,1942,65,1943,65,1944,65,1945,65,1946,65,1947,65,1948,65,1949,65,1950,65,1951,65,1952,65,1953,65,1954,65,1955,65,1956,65,1957,65,1958,65,1959,65,1960,65,1961,65,1962,65,1963,65,1964,65,1965,65,1966,65,1967,65,1968,65,1969,65,1970,65,1971,65,1972,65,1973,65,1974,65,1975,65,1976,65,1977,65,1978,65,1979,65,1980,65,1981,65,1982,65,1983,65,1984,65,1985,65,1986,65,1987,65,1988,65,1989,65,1990,65,1991,65,1992,65,1993,65,1994,65,1995,65,1996,65,1997,65,1998,65,1999,65,2000,65,2001,65,2002,65,2003,65,2004,65,2005,65,2006,65,2007,65,2008,65,2009,65,2010,65,2011,65,2012,65,2013,65,2014,65,2015,65,2016,65,2017,65,2018,65,2019,65,2020,65,2021,65,2022,65,2023,65,2024,65,2025,65,2026,65,2027,65,2028,65,2029,65,2030,65,2031,65,2032,65,2033,65,2034,65,2035,65,2036,65,2037,65,2038,65,2039,65,2040,65,2041,65,2042,65,2043,65,2044,65,2045,65,2046,65,2047,65,2048,65,2049,65,2050,65,2051,65,2052,65,2053,65,2054,65,2055,65,2056,65,2057,65,2058,65,2059,65,2060,65,2061,65,2062,65,2063,65,2064,65,2065,65,2066,65,2067,65,2068,65,2069,65,2070,65,2071,65,2072,65,2073,65,2074,65,2075,65,2076,65,2077,65,2078,65,2079,65,2080,65,2081,65,2082,65,2083,65,2084,65,2085,65,2086,65,2087,65,2088,65,2089,65,2090,65,2091,65,2092,65,2093,65,2094,65,2095,65,2096,65,2097,65,2098,65,2099,65,2100,65,2101,65,2102,65,2103,65,2104,65,2105,65,2106,65,2107,65,2108,65,2109,65,2110,65,2111,65,2112,65,2113,65,2114,65,2115,65,2116,65,2117,65,2118,65,2119,65,2120,65,2121,65,2122,65,2123,65,2124,65,2125,65,2126,65,2127,65,2128,65,2129,65,2130,65,2131,65,2132,65,2133,65,2134,65,2135,65,2136,65,2137,65,2138,65,2139,65,2140,65,2141,65,2142,65,2143,65,2144,65,2145,65,2146,65,2147,65,2148,65,2149,65,2150,65,2151,65,2152,65,2153,65,2154,65,2155,65,2156,65,2157,65,2158,65,2159,65,2160,65,2161,65,2162,65,2163,65,2164,65,2165,65,2166,65,2167,65,2168,65,2169,65,2170,65,2171,65,2172,65,2173,65,2174,65,2175,65,2176,65,2177,65,2178,65,2179,65,2180,65,2181,65,2182,65,2183,65,2184,65,2185,65,2186,65,2187,65,2188,65,2189,65,2190,65,2191,65,2192,65,2193,65,2194,65,2195,65,2196,65,2197,65,2198,65,2199,65,2200,65,2201,65,2202,65,2203,65,2204,65,2205,65,2206,65,2207,65,2208,65,2209,65,2210,65,2211,65,2212,65,2213,65,2214,65,2215,65,2216,65,2217,65,2218,65,2219,65,2220,65,2221,65,2222,65,2223,65,2224,65,2225,65,2226,65,2227,65,2228,65,2229,65,2230,65,2231,65,2232,65,2233,150,2234,150,2235,150,2236,150,2237,150,2238,150,2239,150,2240,150,2241,150,2242,150,2243,150,2244,150,2245,150,2246,150,2247,150,2248,150,2249,150,2250,150,2251,150,2252,150,2253,150,2254,150,2255,150,2256,150,2257,150,2258,150,2259,150,2260,150,2261,150,2262,150,2263,150,2264,150,2265,150,2266,150,2267,150,2268,150,2269,150,2270,150,2271,150,2272,150,2273,150,2274,150,2275,150,2276,150,2277,150,2278,150,2279,150,2280,150,2281,150,2282,150,2283,150,2284,150,2285,150,2286,150,2287,150,2288,150,2289,150,2290,150,2291,150,2292,150,2293,150,2294,150,2295,150,2296,150,2297,150,2298,150,2299,150,2300,150,2301,150,2302,150,2303,150,2304,150,2305,150,2306,150,2307,150,2308,150,2309,150,2310,150,2311,150,2312,150,2313,150,2314,150,2315,150,2316,150,2317,150,2318,150,2319,150,2320,150,2321,150,2322,150,2323,150,2324,150,2325,150,2326,150,2327,150,2328,150,2329,150,2330,150,2331,150,2332,150,2333,150,2334,150,2335,150,2336,150,2337,150,2338,150,2339,150,2340,150,2341,150,2342,150,2343,150,2344,150,2345,150,2346,150,2347,150,2348,150,2349,150,2350,150,2351,150,2352,150,2353,150,2354,150,2355,150,2356,150,2357,150,2358,150,2359,150,2360,150,2361,150,2362,150,2363,150,2364,150,2365,150,2366,150,2367,150,2368,150,2369,150,2370,150,2371,150,2372,150,2373,150,2374,150,2375,150,2376,150,2377,150,2378,150,2379,150,2380,150,2381,150,2382,150,2383,150,2384,150,2385,150,2386,150,2387,150,2388,150,2389,150,2390,150,2391,150,2392,150,2393,150,2394,150,2395,150,2396,150,2397,150,2398,150,2399,150,2400,150,2401,150,2402,150,2403,150,2404,150,2405,150,2406,150,2407,150,2408,150,2409,150,2410,150,2411,150,2412,150,2413,150,2414,150,2415,150,2416,150,2417,150,2418,150,2419,150,2420,150,2421,150,2422,150,2423,150,2424,150,2425,150,2426,150,2427,150,2428,150,2429,150,2430,150,2431,150,2432,150,2433,150,2434,150,2435,150,2436,150,2437,150,2438,150,2439,150,2440,150,2441,150,2442,150,2443,150,2444,150,2445,150,2446,150,2447,150,2448,150,2449,150,2450,150,2451,150,2452,150,2453,150,2454,150,2455,150,2456,150,2457,150,2458,150,2459,150,2460,150,2461,150,2462,150,2463,150,2464,150,2465,150,2466,150,2467,150,2468,150,2469,150,2470,150,2471,150,2472,150,2473,150,2474,150,2475,150,2476,150,2477,150,2478,150,2479,150,2480,150,2481,150,2482,150,2483,150,2484,150,2485,150,2486,150,2487,150,2488,150,2489,150,2490,150,2491,150,2492,150,2493,150,2494,150,2495,150,2496,150,2497,150,2498,150,2499,150,2500,150,2501,150,2502,150,2503,150,2504,150,2505,150,2506,150,2507,150,2508,150,2509,150,2510,150,2511,150,2512,150,2513,150,2514,150,2515,150,2516,150,2517,150,2518,150,2519,150,2520,150,2521,150,2522,150,2523,150,2524,150,2525,150,2526,150,2527,150,2528,150,2529,150,2530,150,2531,150,2532,150,2533,150,2534,150,2535,150,2536,150,2537,150,2538,150,2539,150,2540,150,2541,150,2542,150,2543,150,2544,150,2545,150,2546,150,2547,150,2548,150,2549,150,2550,150,2551,150,2552,150,2553,150,2554,150,2555,150,2556,150,2557,150,2558,150,2559,150,2560,150,2561,150,2562,150,2563,150,2564,150,2565,150,2566,150,2567,150,2568,150,2569,150,2570,150,2571,150,2572,150,2573,150,2574,150,2575,150,2576,150,2577,150,2578,150,2579,150,2580,150,2581,150,2582,150,2583,150,2584,150,2585,150,2586,150,2587,150,2588,150,2589,150,2590,150,2591,150,2592,150,2593,150,2594,150,2595,150,2596,150,2597,150,2598,150,2599,150,2600,150,2601,150,2602,150,2603,150,2604,150)
.param PLEAK=1.99526e-05
.param LOSS=0.891251 KDIV=0.654 KTRIM=0.16 KFF=1.0
.step param run 1 2604 1
.func tm(x) {x-TPER*floor(x/TPER)}
.func rc(u) {if(u<TLEAD,0,if(u<TLEAD+TR,0.5*(1-cos(pi*(u-TLEAD)/TR)),if(u<TLEAD+TDIT,1,if(u<TE,0.5*(1+cos(pi*(u-TLEAD-TDIT)/TR)),0))))}
.func env(x) {rc(tm(floor(x/TQ)*TQ))}
.func wnd(u,a,b) {(u>=a)*(u<b)}
.func onw(x,a,b) {max(wnd(tm(x),a,b),(x>=TPER)*wnd(tm(x)+TPER,a,b))}
V5 v5 0 5
* firmware reference: raised-cosine amplitude table predistorted by the detector law (table of
* run 2026-09-28-det-char-biased), 12-bit PWM updated every 32.768 us, 2-pole RC
* DB: detector tap factor (1, or BOOST at the 0.5 and 1 W steps of the revision 1 design)
Bref refraw 0 V=table(DB*ASET*env(time),-1,0,0,0,0.05,8.27946e-05,0.1,0.000330664,0.2,0.00131475,0.35,0.00396146,0.6,0.0111292,1,0.0278097,1.7,0.0647408,3,0.142508,5,0.270735,9,0.536205,15,0.943429,22.36,1.44789,28,1.83699)
R1 refraw r1 4.7k
C1 r1 0 10n
R2 r1 vref 4.7k
C2 vref 0 10n
* error amplifier: difference integrator about a 2.5 V mid-rail (bipolar trim), modelled as an ideal
* integrator with rails: V(out) = 2.5 V + integral of (Vref - Vdet + VOS)/(RIN*CF), limited to 0..5 V,
* reset to 2.5 V while parked; it does not load the reference or the detector (buffered inputs, e.g.
* an MCP6002 difference integrator with the spare half as buffer; WP-PDR-22 sets the circuit).
* VOS is the residual input offset after the firmware zero calibration.
* revision 1: the integrator input is opened while parked, so the trim is HELD between elements
* (no reset); it starts at mid-rail at t = 0 (power-on)
Gi 0 xi value={(1-V(park))*(V(vref)-V(detf)+VOS)/10000}
Ci xi 0 4.48e-09
Dih xi vh DI
Dil vl xi DI
Vh vh 0 2.485
Vl vl 0 -2.485
Bo out 0 V=2.5+V(xi)
.model DI D(Ron=1 Roff=1e12 Vfwd=0)
* feedforward VGG table (second 12-bit PWM, same update and 2-pole RC as the reference): the nominal
* inverse PA curve at the run's drain voltage for KFF of the wanted amplitude, 0 V when the table is 0
* feedforward foot below the graphs at SUB dB/V (the per-unit calibration reads it down to the
* detector's visibility floor)
.func ffd(x) {10*log10(max((KFF*ASET*x)**2/100/LOSS/SCALE,1e-20)*1e3)}
Bff ffraw 0 V=(env(time)>0)*max(table(max(ffd(env(time)),20.5154),19.5154,2.32,20.5154,2.32,21.9368,2.34,23.1848,2.36,24.3838,2.38,25.5509,2.4,26.5753,2.42,27.58,2.44,28.5058,2.46,29.3797,2.48,30.0903,2.5,30.8095,2.52,31.2759,2.54,32.1018,2.56,32.7779,2.58,33.4682,2.6,33.9358,2.62,34.4373,2.64,34.8966,2.66,35.3405,2.68,35.7068,2.7,36.1383,2.72,36.4895,2.74,36.7686,2.76,36.9978,2.78,37.2139,2.8,37.4003,2.82,37.5709,2.84,37.734,2.86,37.8522,2.88,38.0028,2.9,38.1122,2.92,38.2265,2.94,38.3248,2.96,38.4164,2.98,38.4956,3,38.5763,3.02,38.6442,3.04,38.7051,3.06,38.7593,3.08,38.8036,3.1,38.8485,3.12,38.8856,3.14,38.9215,3.16,38.9492,3.18,38.9787,3.2,39.0097,3.22,39.0316,3.24,39.0528,3.26,39.0656,3.28,39.0856,3.3,39.1049,3.32,39.1242,3.34,39.1415,3.36,39.1548,3.38,39.1693,3.4,39.242,3.5,39.3215,3.6,39.4076,3.7,39.4905,3.8,39.5716,3.9)-max(20.5154-ffd(env(time)),0)/SUB,0)
R3 ffraw f1 4.7k
C3 f1 0 10n
R4 f1 ff 4.7k
C4 ff 0 10n
* VGG node: feedforward plus the loop trim, KTRIM volts per volt of the error amplifier about
* mid-rail (+/-0.25 V authority), not below 0 V (Schottky clamp), 1.77 k, 10 nF
Bvt vt 0 V=max(KTRIM*(V(out)-2.5)+V(ff),0)
Rth vt vgg 1770
Cg vgg 0 1e-08
* clamps (open collector, on at reset): VGG node held low and integrator parked outside the window
* ramp start .. drive gate
Bpk park 0 V=1-onw(time,TLEAD,TE+TG)
S1 vgg 0 park 0 SWC
S4 vref 0 park 0 SWC
.model SWC SW(Ron=10 Roff=1e9 Vt=0.5 Vh=0.05)
* PA static transfer (dBm at the reference drain voltage) scaled for the drain voltage, curve shifted
* by VSH (module-to-module threshold corner)
* PA sub-threshold extension below 2.32 V at SUB dB/V (65, 100 or 150; the firmware table follows it)
Bpg pg 0 V=SCALE*pow(10,(table(max(V(vgg)-VSH,2.32),1.32,20.5154,2.32,20.5154,2.34,21.9368,2.36,23.1848,2.38,24.3838,2.4,25.5509,2.42,26.5753,2.44,27.58,2.46,28.5058,2.48,29.3797,2.5,30.0903,2.52,30.8095,2.54,31.2759,2.56,32.1018,2.58,32.7779,2.6,33.4682,2.62,33.9358,2.64,34.4373,2.66,34.8966,2.68,35.3405,2.7,35.7068,2.72,36.1383,2.74,36.4895,2.76,36.7686,2.78,36.9978,2.8,37.2139,2.82,37.4003,2.84,37.5709,2.86,37.734,2.88,37.8522,2.9,38.0028,2.92,38.1122,2.94,38.2265,2.96,38.3248,2.98,38.4164,3,38.4956,3.02,38.5763,3.04,38.6442,3.06,38.7051,3.08,38.7593,3.1,38.8036,3.12,38.8485,3.14,38.8856,3.16,38.9215,3.18,38.9492,3.2,38.9787,3.22,39.0097,3.24,39.0316,3.26,39.0528,3.28,39.0656,3.3,39.0856,3.32,39.1049,3.34,39.1242,3.36,39.1415,3.38,39.1548,3.4,39.1693,3.5,39.242,3.6,39.3215,3.7,39.4076,3.8,39.4905,3.9,39.5716)-SUB*max(2.32-(V(vgg)-VSH),0)-30)/10)
* drive gate: CLK1 enable and GVA-84+ bias, 10 us
Bd dr0 0 V=onw(time,TCLK,TE+TG)
Rd dr0 dr 1k
Cd dr 0 10n
* relay pole A contact (closes 7.5 ms after the relay command)
Bc cont 0 V=time>TC
* power and amplitude at the 50 ohm load (after 0.5 dB LPF and relay loss); PLEAK is the output with
* the gate off and the exciter driven (estimate, see the record)
Bpl pl 0 V=V(cont)*V(dr)*(V(pg)+PLEAK)*LOSS
Bal al 0 V=sqrt(100*max(V(pl),0))
* detector static law from run 2026-09-28-det-char-biased and its 4.7 us video pole (10 k, 470 pF);
* DB is the tap factor (the diode sees DB times the amplitude of the 5 W design tap)
Bdet d0 0 V=table(DB*V(al),-1,0,0,0,0.05,8.27946e-05,0.1,0.000330664,0.2,0.00131475,0.35,0.00396146,0.6,0.0111292,1,0.0278097,1.7,0.0647408,3,0.142508,5,0.270735,9,0.536205,15,0.943429,22.36,1.44789,28,1.83699)
Rv d0 detf 1k
Cv detf 0 4.7n
* op-amp macro: gm stage, Aol 112 dB, GBW 1 MHz, internal node and output limited to the rails
.subckt OPA inp inn out vcc
G1 0 x inp inn 1m
Rx x 0 4e8
Cx x 0 159p
Dhi x vcc DI
Dlo 0 x DI
Bo o 0 V=limit(V(x),0.015,V(vcc)-0.015)
Ro o out 20
.model DI D(Ron=1 Roff=1e12 Vfwd=0)
.ends OPA
.save V(al)
.tran 0 0.048 0.0 20u
.options reltol=1e-4
.end
