* keying_a5_sweep0.cir: keying envelope loop, TS-012 finalist A5 (RA07M1317M module, VGG loop), revision 0 mitigated design (trim reset at every element), threshold sweep at 7.4 V pack
* cwht WP-PDR-22 pre-order item; generated by hardware/sim/tx-keying/keying_run.py; record
* docs/design/analysis/keying-ts012.md. Envelope-domain behavioural deck (no RF carrier).
* Steps: for each corner in turn, the packs [7.4] V (drain [6.7] V),
* within each the power steps [0.5, 5.0] W, within each the 3, 5, 8 ms (10-90 %) settings:
*   runs 1..6: PA curve shifted -0.300 V, error-amplifier offset +0.0 mV
*   runs 7..12: PA curve shifted -0.250 V, error-amplifier offset +0.0 mV
*   runs 13..18: PA curve shifted -0.200 V, error-amplifier offset +0.0 mV
*   runs 19..24: PA curve shifted -0.150 V, error-amplifier offset +0.0 mV
*   runs 25..30: PA curve shifted -0.100 V, error-amplifier offset +0.0 mV
*   runs 31..36: PA curve shifted -0.050 V, error-amplifier offset +0.0 mV
*   runs 37..42: PA curve shifted +0.000 V, error-amplifier offset +0.0 mV
*   runs 43..48: PA curve shifted +0.050 V, error-amplifier offset +0.0 mV
*   runs 49..54: PA curve shifted +0.100 V, error-amplifier offset +0.0 mV
*   runs 55..60: PA curve shifted +0.150 V, error-amplifier offset +0.0 mV
*   runs 61..66: PA curve shifted +0.200 V, error-amplifier offset +0.0 mV
*   runs 67..72: PA curve shifted +0.250 V, error-amplifier offset +0.0 mV
*   runs 73..78: PA curve shifted +0.300 V, error-amplifier offset +0.0 mV
* 50 WPM continuous dits: key down 24 ms, up 24 ms; relay command at key-down of element 1,
* contact closed at 7.5 ms; CLK1 and GVA-84+ bias on at 8 ms; ramp start 10 ms after each key-down;
* drive gated off 1 ms after each ramp end; VGG and integrator clamps applied at the gate.
.param TPER=0.048 TDIT=0.024 TLEAD=0.01 TCLK=0.008 TC=0.0075 TQ=3.2768e-05 TG=0.001
.param run=1
.param TSET=table(run,1,0.003,2,0.005,3,0.008,4,0.003,5,0.005,6,0.008,7,0.003,8,0.005,9,0.008,10,0.003,11,0.005,12,0.008,13,0.003,14,0.005,15,0.008,16,0.003,17,0.005,18,0.008,19,0.003,20,0.005,21,0.008,22,0.003,23,0.005,24,0.008,25,0.003,26,0.005,27,0.008,28,0.003,29,0.005,30,0.008,31,0.003,32,0.005,33,0.008,34,0.003,35,0.005,36,0.008,37,0.003,38,0.005,39,0.008,40,0.003,41,0.005,42,0.008,43,0.003,44,0.005,45,0.008,46,0.003,47,0.005,48,0.008,49,0.003,50,0.005,51,0.008,52,0.003,53,0.005,54,0.008,55,0.003,56,0.005,57,0.008,58,0.003,59,0.005,60,0.008,61,0.003,62,0.005,63,0.008,64,0.003,65,0.005,66,0.008,67,0.003,68,0.005,69,0.008,70,0.003,71,0.005,72,0.008,73,0.003,74,0.005,75,0.008,76,0.003,77,0.005,78,0.008)
.param TR={TSET/0.590334}
.param TE={TLEAD+TDIT+TR}
.param SCALE=table(run,1,0.875081,2,0.875081,3,0.875081,4,0.875081,5,0.875081,6,0.875081,7,0.875081,8,0.875081,9,0.875081,10,0.875081,11,0.875081,12,0.875081,13,0.875081,14,0.875081,15,0.875081,16,0.875081,17,0.875081,18,0.875081,19,0.875081,20,0.875081,21,0.875081,22,0.875081,23,0.875081,24,0.875081,25,0.875081,26,0.875081,27,0.875081,28,0.875081,29,0.875081,30,0.875081,31,0.875081,32,0.875081,33,0.875081,34,0.875081,35,0.875081,36,0.875081,37,0.875081,38,0.875081,39,0.875081,40,0.875081,41,0.875081,42,0.875081,43,0.875081,44,0.875081,45,0.875081,46,0.875081,47,0.875081,48,0.875081,49,0.875081,50,0.875081,51,0.875081,52,0.875081,53,0.875081,54,0.875081,55,0.875081,56,0.875081,57,0.875081,58,0.875081,59,0.875081,60,0.875081,61,0.875081,62,0.875081,63,0.875081,64,0.875081,65,0.875081,66,0.875081,67,0.875081,68,0.875081,69,0.875081,70,0.875081,71,0.875081,72,0.875081,73,0.875081,74,0.875081,75,0.875081,76,0.875081,77,0.875081,78,0.875081)
.param VSH=table(run,1,-0.3,2,-0.3,3,-0.3,4,-0.3,5,-0.3,6,-0.3,7,-0.25,8,-0.25,9,-0.25,10,-0.25,11,-0.25,12,-0.25,13,-0.2,14,-0.2,15,-0.2,16,-0.2,17,-0.2,18,-0.2,19,-0.15,20,-0.15,21,-0.15,22,-0.15,23,-0.15,24,-0.15,25,-0.1,26,-0.1,27,-0.1,28,-0.1,29,-0.1,30,-0.1,31,-0.05,32,-0.05,33,-0.05,34,-0.05,35,-0.05,36,-0.05,37,0,38,0,39,0,40,0,41,0,42,0,43,0.05,44,0.05,45,0.05,46,0.05,47,0.05,48,0.05,49,0.1,50,0.1,51,0.1,52,0.1,53,0.1,54,0.1,55,0.15,56,0.15,57,0.15,58,0.15,59,0.15,60,0.15,61,0.2,62,0.2,63,0.2,64,0.2,65,0.2,66,0.2,67,0.25,68,0.25,69,0.25,70,0.25,71,0.25,72,0.25,73,0.3,74,0.3,75,0.3,76,0.3,77,0.3,78,0.3)
.param VOS=table(run,1,0,2,0,3,0,4,0,5,0,6,0,7,0,8,0,9,0,10,0,11,0,12,0,13,0,14,0,15,0,16,0,17,0,18,0,19,0,20,0,21,0,22,0,23,0,24,0,25,0,26,0,27,0,28,0,29,0,30,0,31,0,32,0,33,0,34,0,35,0,36,0,37,0,38,0,39,0,40,0,41,0,42,0,43,0,44,0,45,0,46,0,47,0,48,0,49,0,50,0,51,0,52,0,53,0,54,0,55,0,56,0,57,0,58,0,59,0,60,0,61,0,62,0,63,0,64,0,65,0,66,0,67,0,68,0,69,0,70,0,71,0,72,0,73,0,74,0,75,0,76,0,77,0,78,0)
.param ASET=table(run,1,7.07107,2,7.07107,3,7.07107,4,22.3607,5,22.3607,6,22.3607,7,7.07107,8,7.07107,9,7.07107,10,22.3607,11,22.3607,12,22.3607,13,7.07107,14,7.07107,15,7.07107,16,22.3607,17,22.3607,18,22.3607,19,7.07107,20,7.07107,21,7.07107,22,22.3607,23,22.3607,24,22.3607,25,7.07107,26,7.07107,27,7.07107,28,22.3607,29,22.3607,30,22.3607,31,7.07107,32,7.07107,33,7.07107,34,22.3607,35,22.3607,36,22.3607,37,7.07107,38,7.07107,39,7.07107,40,22.3607,41,22.3607,42,22.3607,43,7.07107,44,7.07107,45,7.07107,46,22.3607,47,22.3607,48,22.3607,49,7.07107,50,7.07107,51,7.07107,52,22.3607,53,22.3607,54,22.3607,55,7.07107,56,7.07107,57,7.07107,58,22.3607,59,22.3607,60,22.3607,61,7.07107,62,7.07107,63,7.07107,64,22.3607,65,22.3607,66,22.3607,67,7.07107,68,7.07107,69,7.07107,70,22.3607,71,22.3607,72,22.3607,73,7.07107,74,7.07107,75,7.07107,76,22.3607,77,22.3607,78,22.3607)
.param VSET=table(run,1,0.414832,2,0.414832,3,0.414832,4,1.45548,5,1.45548,6,1.45548,7,0.414832,8,0.414832,9,0.414832,10,1.45548,11,1.45548,12,1.45548,13,0.414832,14,0.414832,15,0.414832,16,1.45548,17,1.45548,18,1.45548,19,0.414832,20,0.414832,21,0.414832,22,1.45548,23,1.45548,24,1.45548,25,0.414832,26,0.414832,27,0.414832,28,1.45548,29,1.45548,30,1.45548,31,0.414832,32,0.414832,33,0.414832,34,1.45548,35,1.45548,36,1.45548,37,0.414832,38,0.414832,39,0.414832,40,1.45548,41,1.45548,42,1.45548,43,0.414832,44,0.414832,45,0.414832,46,1.45548,47,1.45548,48,1.45548,49,0.414832,50,0.414832,51,0.414832,52,1.45548,53,1.45548,54,1.45548,55,0.414832,56,0.414832,57,0.414832,58,1.45548,59,1.45548,60,1.45548,61,0.414832,62,0.414832,63,0.414832,64,1.45548,65,1.45548,66,1.45548,67,0.414832,68,0.414832,69,0.414832,70,1.45548,71,1.45548,72,1.45548,73,0.414832,74,0.414832,75,0.414832,76,1.45548,77,1.45548,78,1.45548)
.param DB=table(run,1,1,2,1,3,1,4,1,5,1,6,1,7,1,8,1,9,1,10,1,11,1,12,1,13,1,14,1,15,1,16,1,17,1,18,1,19,1,20,1,21,1,22,1,23,1,24,1,25,1,26,1,27,1,28,1,29,1,30,1,31,1,32,1,33,1,34,1,35,1,36,1,37,1,38,1,39,1,40,1,41,1,42,1,43,1,44,1,45,1,46,1,47,1,48,1,49,1,50,1,51,1,52,1,53,1,54,1,55,1,56,1,57,1,58,1,59,1,60,1,61,1,62,1,63,1,64,1,65,1,66,1,67,1,68,1,69,1,70,1,71,1,72,1,73,1,74,1,75,1,76,1,77,1,78,1)
.param PLEAK=1.99526e-05
.param LOSS=0.891251 KDIV=0.654 KTRIM=0.1 KFF=1.0
.step param run 1 78 1
.func tm(x) {x-TPER*floor(x/TPER)}
.func rc(u) {if(u<TLEAD,0,if(u<TLEAD+TR,0.5*(1-cos(pi*(u-TLEAD)/TR)),if(u<TLEAD+TDIT,1,if(u<TE,0.5*(1+cos(pi*(u-TLEAD-TDIT)/TR)),0))))}
.func env(x) {rc(tm(floor(x/TQ)*TQ))}
.func wnd(u,a,b) {(u>=a)*(u<b)}
.func onw(x,a,b) {max(wnd(tm(x),a,b),(x>=TPER)*wnd(tm(x)+TPER,a,b))}
V5 v5 0 5
* firmware reference: raised-cosine amplitude table predistorted by the detector law (table of
* run 2026-09-28-det-char-biased), 12-bit PWM updated every 32.768 us, 2-pole RC
* DB: detector tap factor (1, or BOOST at the 0.5 and 1 W steps of the revision 1 design)
Bref refraw 0 V=table(DB*ASET*env(time),-1,0,0,0,0.05,8.27946e-05,0.1,0.000330664,0.2,0.00131475,0.35,0.00396146,0.6,0.0111292,1,0.0278097,1.7,0.0647408,3,0.142508,5,0.270735,9,0.536205,15,0.943429,22.36,1.44789,28,1.83699)
R1 refraw r1 4.7k
C1 r1 0 10n
R2 r1 vref 4.7k
C2 vref 0 10n
* error amplifier: difference integrator about a 2.5 V mid-rail (bipolar trim), modelled as an ideal
* integrator with rails: V(out) = 2.5 V + integral of (Vref - Vdet + VOS)/(RIN*CF), limited to 0..5 V,
* reset to 2.5 V while parked; it does not load the reference or the detector (buffered inputs, e.g.
* an MCP6002 difference integrator with the spare half as buffer; WP-PDR-22 sets the circuit).
* VOS is the residual input offset after the firmware zero calibration.
Gi 0 xi value={(V(vref)-V(detf)+VOS)/10000}
Ci xi 0 2.8e-09
Dih xi vh DI
Dil vl xi DI
Vh vh 0 2.485
Vl vl 0 -2.485
S2 xi 0 park 0 SWC
Bo out 0 V=2.5+V(xi)
.model DI D(Ron=1 Roff=1e12 Vfwd=0)
* feedforward VGG table (second 12-bit PWM, same update and 2-pole RC as the reference): the nominal
* inverse PA curve at the run's drain voltage for KFF of the wanted amplitude, 0 V when the table is 0
Bff ffraw 0 V=(env(time)>0)*max(table(10*log10(max((KFF*ASET*env(time))**2/100/LOSS/SCALE,1e-20)*1e3),-279.485,-0.68,-229.485,-0.18,-179.485,0.32,-129.485,0.82,-79.4846,1.32,-29.4846,1.82,20.5154,2.32,21.9368,2.34,23.1848,2.36,24.3838,2.38,25.5509,2.4,26.5753,2.42,27.58,2.44,28.5058,2.46,29.3797,2.48,30.0903,2.5,30.8095,2.52,31.2759,2.54,32.1018,2.56,32.7779,2.58,33.4682,2.6,33.9358,2.62,34.4373,2.64,34.8966,2.66,35.3405,2.68,35.7068,2.7,36.1383,2.72,36.4895,2.74,36.7686,2.76,36.9978,2.78,37.2139,2.8,37.4003,2.82,37.5709,2.84,37.734,2.86,37.8522,2.88,38.0028,2.9,38.1122,2.92,38.2265,2.94,38.3248,2.96,38.4164,2.98,38.4956,3,38.5763,3.02,38.6442,3.04,38.7051,3.06,38.7593,3.08,38.8036,3.1,38.8485,3.12,38.8856,3.14,38.9215,3.16,38.9492,3.18,38.9787,3.2,39.0097,3.22,39.0316,3.24,39.0528,3.26,39.0656,3.28,39.0856,3.3,39.1049,3.32,39.1242,3.34,39.1415,3.36,39.1548,3.38,39.1693,3.4,39.242,3.5,39.3215,3.6,39.4076,3.7,39.4905,3.8,39.5716,3.9),0)
R3 ffraw f1 4.7k
C3 f1 0 10n
R4 f1 ff 4.7k
C4 ff 0 10n
* VGG node: feedforward plus the loop trim, KTRIM volts per volt of the error amplifier about
* mid-rail (+/-0.25 V authority), not below 0 V (Schottky clamp), 1.77 k, 10 nF
Bvt vt 0 V=max(KTRIM*(V(out)-2.5)+V(ff),0)
Rth vt vgg 1770
Cg vgg 0 1e-08
* clamps (open collector, on at reset): VGG node held low and integrator parked outside the window
* ramp start .. drive gate
Bpk park 0 V=1-onw(time,TLEAD,TE+TG)
S1 vgg 0 park 0 SWC
S4 vref 0 park 0 SWC
.model SWC SW(Ron=10 Roff=1e9 Vt=0.5 Vh=0.05)
* PA static transfer (dBm at the reference drain voltage) scaled for the drain voltage, curve shifted
* by VSH (module-to-module threshold corner)
Bpg pg 0 V=SCALE*pow(10,(table(V(vgg)-VSH,-0.68,-279.485,-0.18,-229.485,0.32,-179.485,0.82,-129.485,1.32,-79.4846,1.82,-29.4846,2.32,20.5154,2.34,21.9368,2.36,23.1848,2.38,24.3838,2.4,25.5509,2.42,26.5753,2.44,27.58,2.46,28.5058,2.48,29.3797,2.5,30.0903,2.52,30.8095,2.54,31.2759,2.56,32.1018,2.58,32.7779,2.6,33.4682,2.62,33.9358,2.64,34.4373,2.66,34.8966,2.68,35.3405,2.7,35.7068,2.72,36.1383,2.74,36.4895,2.76,36.7686,2.78,36.9978,2.8,37.2139,2.82,37.4003,2.84,37.5709,2.86,37.734,2.88,37.8522,2.9,38.0028,2.92,38.1122,2.94,38.2265,2.96,38.3248,2.98,38.4164,3,38.4956,3.02,38.5763,3.04,38.6442,3.06,38.7051,3.08,38.7593,3.1,38.8036,3.12,38.8485,3.14,38.8856,3.16,38.9215,3.18,38.9492,3.2,38.9787,3.22,39.0097,3.24,39.0316,3.26,39.0528,3.28,39.0656,3.3,39.0856,3.32,39.1049,3.34,39.1242,3.36,39.1415,3.38,39.1548,3.4,39.1693,3.5,39.242,3.6,39.3215,3.7,39.4076,3.8,39.4905,3.9,39.5716)-30)/10)
* drive gate: CLK1 enable and GVA-84+ bias, 10 us
Bd dr0 0 V=onw(time,TCLK,TE+TG)
Rd dr0 dr 1k
Cd dr 0 10n
* relay pole A contact (closes 7.5 ms after the relay command)
Bc cont 0 V=time>TC
* power and amplitude at the 50 ohm load (after 0.5 dB LPF and relay loss); PLEAK is the output with
* the gate off and the exciter driven (estimate, see the record)
Bpl pl 0 V=V(cont)*V(dr)*(V(pg)+PLEAK)*LOSS
Bal al 0 V=sqrt(100*max(V(pl),0))
* detector static law from run 2026-09-28-det-char-biased and its 4.7 us video pole (10 k, 470 pF);
* DB is the tap factor (the diode sees DB times the amplitude of the 5 W design tap)
Bdet d0 0 V=table(DB*V(al),-1,0,0,0,0.05,8.27946e-05,0.1,0.000330664,0.2,0.00131475,0.35,0.00396146,0.6,0.0111292,1,0.0278097,1.7,0.0647408,3,0.142508,5,0.270735,9,0.536205,15,0.943429,22.36,1.44789,28,1.83699)
Rv d0 detf 1k
Cv detf 0 4.7n
* op-amp macro: gm stage, Aol 112 dB, GBW 1 MHz, internal node and output limited to the rails
.subckt OPA inp inn out vcc
G1 0 x inp inn 1m
Rx x 0 4e8
Cx x 0 159p
Dhi x vcc DI
Dlo 0 x DI
Bo o 0 V=limit(V(x),0.015,V(vcc)-0.015)
Ro o out 20
.model DI D(Ron=1 Roff=1e12 Vfwd=0)
.ends OPA
.save V(al)
.tran 0 0.384 0.095 20u
.options reltol=1e-4
.end
