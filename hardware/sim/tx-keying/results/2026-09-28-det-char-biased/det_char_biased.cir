* det_char_biased.cir: static transfer of the biased ALC detector proposed for the mitigated keying loop
* cwht WP-PDR-22 pre-order keying analysis, hardware/sim/tx-keying (analysis record docs/design/analysis/keying-ts012.md)
* Same 146 MHz source and 2.2 k / 180 ohm tap as det_char.cir. Shunt detector: 100 pF coupling, 1N5711W to
* ground forward-biased at about 21 uA from the 5 V bus through 220 k (video resistance about 1.3 k instead
* of about 0.9 M at zero bias), 10 k series output with a hold capacitor. A second 1N5711W with the same
* 220 k bias (the spare diode in the TS-012 BOM) gives the no-signal reference: the detected signal is
* V(c) - V(out), which rises with RF and cancels the diode forward drop and its temperature slope to the
* extent the two diodes match. The hold is 47 pF here (0.5 us, settled in 4 us); the envelope deck uses
* 470 pF (4.7 us video pole). Output: .meas vdet (settled mean from 3 to 4 us) per amplitude.
* Diode: HSMS-280x SPICE parameters as in det_char.cir (surrogate for the 1N5711W; estimate).
* Maximum step 0.25 ns with Gear integration: 0.0625 ns agrees within 0.3 % (check of 2026-09-28).
.param A=1
V1 load 0 SIN(0 {A} 146Meg)
Rt load tap 2.2k
Rs tap 0 180
Cc tap n 100p
D1 n 0 D5711
Rb v5 n 220k
V5 v5 0 5
Rf n out 10k
Co out 0 47p
D2 c 0 D5711
Rb2 v5 c 220k
.model D5711 D(Is=3e-8 N=1.08 Rs=30 Cjo=1.6p Vj=0.65 M=0.5 Eg=0.69 Xti=2 BV=75 Ibv=1e-5)
.step param A list 0.05 0.1 0.2 0.35 0.6 1 1.7 3 5 9 15 22.36 28
.options method=gear
.tran 0 4u 0 0.25n
.meas tran vdet AVG V(c)-V(out) FROM 3u TO 4u
.save V(out) V(c)
.end
