* keying_a4_fix.cir: keying envelope loop, TS-012 finalist A4 (AFT05MS004N discrete, gate-bias loop), revision 1 design (held trim +/-0.4 V, detector tap +7 dB at 0.5 and 1 W, per-unit calibrated feedforward)
* cwht WP-PDR-22 pre-order item; generated by hardware/sim/tx-keying/keying_run.py; record
* docs/design/analysis/keying-ts012.md. Envelope-domain behavioural deck (no RF carrier).
* Steps: for each corner in turn, the packs [6.4, 7.4, 8.4] V (drain [6.1, 7.1, 8.1] V),
* within each the power steps [0.5, 1.0, 2.0, 5.0] W, within each the 3, 5, 8 ms (10-90 %) settings:
*   runs 1..36: PA curve shifted +0.000 V, error-amplifier offset +0.0 mV
*   runs 37..72: PA curve shifted -0.179 V, error-amplifier offset +1.0 mV
*   runs 73..108: PA curve shifted +0.096 V, error-amplifier offset -1.0 mV
*   runs 109..144: PA curve shifted -0.107 V, error-amplifier offset +1.0 mV
*   runs 145..180: PA curve shifted +0.190 V, error-amplifier offset -1.0 mV
* 50 WPM continuous dits: key down 24 ms, up 24 ms; relay command at key-down of element 1,
* contact closed at 7.5 ms; CLK1 and GVA-84+ bias on at 8 ms; ramp start 10 ms after each key-down;
* drive gated off 1 ms after each ramp end; VGG and integrator clamps applied at the gate.
.param TPER=0.048 TDIT=0.024 TLEAD=0.01 TCLK=0.008 TC=0.0075 TQ=3.2768e-05 TG=0.001
.param run=1
.param TSET=table(run,1,0.003,2,0.005,3,0.008,4,0.003,5,0.005,6,0.008,7,0.003,8,0.005,9,0.008,10,0.003,11,0.005,12,0.008,13,0.003,14,0.005,15,0.008,16,0.003,17,0.005,18,0.008,19,0.003,20,0.005,21,0.008,22,0.003,23,0.005,24,0.008,25,0.003,26,0.005,27,0.008,28,0.003,29,0.005,30,0.008,31,0.003,32,0.005,33,0.008,34,0.003,35,0.005,36,0.008,37,0.003,38,0.005,39,0.008,40,0.003,41,0.005,42,0.008,43,0.003,44,0.005,45,0.008,46,0.003,47,0.005,48,0.008,49,0.003,50,0.005,51,0.008,52,0.003,53,0.005,54,0.008,55,0.003,56,0.005,57,0.008,58,0.003,59,0.005,60,0.008,61,0.003,62,0.005,63,0.008,64,0.003,65,0.005,66,0.008,67,0.003,68,0.005,69,0.008,70,0.003,71,0.005,72,0.008,73,0.003,74,0.005,75,0.008,76,0.003,77,0.005,78,0.008,79,0.003,80,0.005,81,0.008,82,0.003,83,0.005,84,0.008,85,0.003,86,0.005,87,0.008,88,0.003,89,0.005,90,0.008,91,0.003,92,0.005,93,0.008,94,0.003,95,0.005,96,0.008,97,0.003,98,0.005,99,0.008,100,0.003,101,0.005,102,0.008,103,0.003,104,0.005,105,0.008,106,0.003,107,0.005,108,0.008,109,0.003,110,0.005,111,0.008,112,0.003,113,0.005,114,0.008,115,0.003,116,0.005,117,0.008,118,0.003,119,0.005,120,0.008,121,0.003,122,0.005,123,0.008,124,0.003,125,0.005,126,0.008,127,0.003,128,0.005,129,0.008,130,0.003,131,0.005,132,0.008,133,0.003,134,0.005,135,0.008,136,0.003,137,0.005,138,0.008,139,0.003,140,0.005,141,0.008,142,0.003,143,0.005,144,0.008,145,0.003,146,0.005,147,0.008,148,0.003,149,0.005,150,0.008,151,0.003,152,0.005,153,0.008,154,0.003,155,0.005,156,0.008,157,0.003,158,0.005,159,0.008,160,0.003,161,0.005,162,0.008,163,0.003,164,0.005,165,0.008,166,0.003,167,0.005,168,0.008,169,0.003,170,0.005,171,0.008,172,0.003,173,0.005,174,0.008,175,0.003,176,0.005,177,0.008,178,0.003,179,0.005,180,0.008)
.param TR={TSET/0.590334}
.param TE={TLEAD+TDIT+TR}
.param SCALE=table(run,1,0.55814,2,0.55814,3,0.55814,4,0.55814,5,0.55814,6,0.55814,7,0.55814,8,0.55814,9,0.55814,10,0.55814,11,0.55814,12,0.55814,13,0.756136,14,0.756136,15,0.756136,16,0.756136,17,0.756136,18,0.756136,19,0.756136,20,0.756136,21,0.756136,22,0.756136,23,0.756136,24,0.756136,25,0.984132,26,0.984132,27,0.984132,28,0.984132,29,0.984132,30,0.984132,31,0.984132,32,0.984132,33,0.984132,34,0.984132,35,0.984132,36,0.984132,37,0.55814,38,0.55814,39,0.55814,40,0.55814,41,0.55814,42,0.55814,43,0.55814,44,0.55814,45,0.55814,46,0.55814,47,0.55814,48,0.55814,49,0.756136,50,0.756136,51,0.756136,52,0.756136,53,0.756136,54,0.756136,55,0.756136,56,0.756136,57,0.756136,58,0.756136,59,0.756136,60,0.756136,61,0.984132,62,0.984132,63,0.984132,64,0.984132,65,0.984132,66,0.984132,67,0.984132,68,0.984132,69,0.984132,70,0.984132,71,0.984132,72,0.984132,73,0.55814,74,0.55814,75,0.55814,76,0.55814,77,0.55814,78,0.55814,79,0.55814,80,0.55814,81,0.55814,82,0.55814,83,0.55814,84,0.55814,85,0.756136,86,0.756136,87,0.756136,88,0.756136,89,0.756136,90,0.756136,91,0.756136,92,0.756136,93,0.756136,94,0.756136,95,0.756136,96,0.756136,97,0.984132,98,0.984132,99,0.984132,100,0.984132,101,0.984132,102,0.984132,103,0.984132,104,0.984132,105,0.984132,106,0.984132,107,0.984132,108,0.984132,109,0.55814,110,0.55814,111,0.55814,112,0.55814,113,0.55814,114,0.55814,115,0.55814,116,0.55814,117,0.55814,118,0.55814,119,0.55814,120,0.55814,121,0.756136,122,0.756136,123,0.756136,124,0.756136,125,0.756136,126,0.756136,127,0.756136,128,0.756136,129,0.756136,130,0.756136,131,0.756136,132,0.756136,133,0.984132,134,0.984132,135,0.984132,136,0.984132,137,0.984132,138,0.984132,139,0.984132,140,0.984132,141,0.984132,142,0.984132,143,0.984132,144,0.984132,145,0.55814,146,0.55814,147,0.55814,148,0.55814,149,0.55814,150,0.55814,151,0.55814,152,0.55814,153,0.55814,154,0.55814,155,0.55814,156,0.55814,157,0.756136,158,0.756136,159,0.756136,160,0.756136,161,0.756136,162,0.756136,163,0.756136,164,0.756136,165,0.756136,166,0.756136,167,0.756136,168,0.756136,169,0.984132,170,0.984132,171,0.984132,172,0.984132,173,0.984132,174,0.984132,175,0.984132,176,0.984132,177,0.984132,178,0.984132,179,0.984132,180,0.984132)
.param VSH=table(run,1,0,2,0,3,0,4,0,5,0,6,0,7,0,8,0,9,0,10,0,11,0,12,0,13,0,14,0,15,0,16,0,17,0,18,0,19,0,20,0,21,0,22,0,23,0,24,0,25,0,26,0,27,0,28,0,29,0,30,0,31,0,32,0,33,0,34,0,35,0,36,0,37,-0.179,38,-0.179,39,-0.179,40,-0.179,41,-0.179,42,-0.179,43,-0.179,44,-0.179,45,-0.179,46,-0.179,47,-0.179,48,-0.179,49,-0.179,50,-0.179,51,-0.179,52,-0.179,53,-0.179,54,-0.179,55,-0.179,56,-0.179,57,-0.179,58,-0.179,59,-0.179,60,-0.179,61,-0.179,62,-0.179,63,-0.179,64,-0.179,65,-0.179,66,-0.179,67,-0.179,68,-0.179,69,-0.179,70,-0.179,71,-0.179,72,-0.179,73,0.096,74,0.096,75,0.096,76,0.096,77,0.096,78,0.096,79,0.096,80,0.096,81,0.096,82,0.096,83,0.096,84,0.096,85,0.096,86,0.096,87,0.096,88,0.096,89,0.096,90,0.096,91,0.096,92,0.096,93,0.096,94,0.096,95,0.096,96,0.096,97,0.096,98,0.096,99,0.096,100,0.096,101,0.096,102,0.096,103,0.096,104,0.096,105,0.096,106,0.096,107,0.096,108,0.096,109,-0.107,110,-0.107,111,-0.107,112,-0.107,113,-0.107,114,-0.107,115,-0.107,116,-0.107,117,-0.107,118,-0.107,119,-0.107,120,-0.107,121,-0.107,122,-0.107,123,-0.107,124,-0.107,125,-0.107,126,-0.107,127,-0.107,128,-0.107,129,-0.107,130,-0.107,131,-0.107,132,-0.107,133,-0.107,134,-0.107,135,-0.107,136,-0.107,137,-0.107,138,-0.107,139,-0.107,140,-0.107,141,-0.107,142,-0.107,143,-0.107,144,-0.107,145,0.19,146,0.19,147,0.19,148,0.19,149,0.19,150,0.19,151,0.19,152,0.19,153,0.19,154,0.19,155,0.19,156,0.19,157,0.19,158,0.19,159,0.19,160,0.19,161,0.19,162,0.19,163,0.19,164,0.19,165,0.19,166,0.19,167,0.19,168,0.19,169,0.19,170,0.19,171,0.19,172,0.19,173,0.19,174,0.19,175,0.19,176,0.19,177,0.19,178,0.19,179,0.19,180,0.19)
.param VOS=table(run,1,0,2,0,3,0,4,0,5,0,6,0,7,0,8,0,9,0,10,0,11,0,12,0,13,0,14,0,15,0,16,0,17,0,18,0,19,0,20,0,21,0,22,0,23,0,24,0,25,0,26,0,27,0,28,0,29,0,30,0,31,0,32,0,33,0,34,0,35,0,36,0,37,0.001,38,0.001,39,0.001,40,0.001,41,0.001,42,0.001,43,0.001,44,0.001,45,0.001,46,0.001,47,0.001,48,0.001,49,0.001,50,0.001,51,0.001,52,0.001,53,0.001,54,0.001,55,0.001,56,0.001,57,0.001,58,0.001,59,0.001,60,0.001,61,0.001,62,0.001,63,0.001,64,0.001,65,0.001,66,0.001,67,0.001,68,0.001,69,0.001,70,0.001,71,0.001,72,0.001,73,-0.001,74,-0.001,75,-0.001,76,-0.001,77,-0.001,78,-0.001,79,-0.001,80,-0.001,81,-0.001,82,-0.001,83,-0.001,84,-0.001,85,-0.001,86,-0.001,87,-0.001,88,-0.001,89,-0.001,90,-0.001,91,-0.001,92,-0.001,93,-0.001,94,-0.001,95,-0.001,96,-0.001,97,-0.001,98,-0.001,99,-0.001,100,-0.001,101,-0.001,102,-0.001,103,-0.001,104,-0.001,105,-0.001,106,-0.001,107,-0.001,108,-0.001,109,0.001,110,0.001,111,0.001,112,0.001,113,0.001,114,0.001,115,0.001,116,0.001,117,0.001,118,0.001,119,0.001,120,0.001,121,0.001,122,0.001,123,0.001,124,0.001,125,0.001,126,0.001,127,0.001,128,0.001,129,0.001,130,0.001,131,0.001,132,0.001,133,0.001,134,0.001,135,0.001,136,0.001,137,0.001,138,0.001,139,0.001,140,0.001,141,0.001,142,0.001,143,0.001,144,0.001,145,-0.001,146,-0.001,147,-0.001,148,-0.001,149,-0.001,150,-0.001,151,-0.001,152,-0.001,153,-0.001,154,-0.001,155,-0.001,156,-0.001,157,-0.001,158,-0.001,159,-0.001,160,-0.001,161,-0.001,162,-0.001,163,-0.001,164,-0.001,165,-0.001,166,-0.001,167,-0.001,168,-0.001,169,-0.001,170,-0.001,171,-0.001,172,-0.001,173,-0.001,174,-0.001,175,-0.001,176,-0.001,177,-0.001,178,-0.001,179,-0.001,180,-0.001)
.param ASET=table(run,1,7.07107,2,7.07107,3,7.07107,4,10,5,10,6,10,7,14.1421,8,14.1421,9,14.1421,10,16.7332,11,16.7332,12,16.7332,13,7.07107,14,7.07107,15,7.07107,16,10,17,10,18,10,19,14.1421,20,14.1421,21,14.1421,22,19.7484,23,19.7484,24,19.7484,25,7.07107,26,7.07107,27,7.07107,28,10,29,10,30,10,31,14.1421,32,14.1421,33,14.1421,34,22.3607,35,22.3607,36,22.3607,37,7.07107,38,7.07107,39,7.07107,40,10,41,10,42,10,43,14.1421,44,14.1421,45,14.1421,46,16.7332,47,16.7332,48,16.7332,49,7.07107,50,7.07107,51,7.07107,52,10,53,10,54,10,55,14.1421,56,14.1421,57,14.1421,58,19.7484,59,19.7484,60,19.7484,61,7.07107,62,7.07107,63,7.07107,64,10,65,10,66,10,67,14.1421,68,14.1421,69,14.1421,70,22.3607,71,22.3607,72,22.3607,73,7.07107,74,7.07107,75,7.07107,76,10,77,10,78,10,79,14.1421,80,14.1421,81,14.1421,82,16.7332,83,16.7332,84,16.7332,85,7.07107,86,7.07107,87,7.07107,88,10,89,10,90,10,91,14.1421,92,14.1421,93,14.1421,94,19.7484,95,19.7484,96,19.7484,97,7.07107,98,7.07107,99,7.07107,100,10,101,10,102,10,103,14.1421,104,14.1421,105,14.1421,106,22.3607,107,22.3607,108,22.3607,109,7.07107,110,7.07107,111,7.07107,112,10,113,10,114,10,115,14.1421,116,14.1421,117,14.1421,118,16.7332,119,16.7332,120,16.7332,121,7.07107,122,7.07107,123,7.07107,124,10,125,10,126,10,127,14.1421,128,14.1421,129,14.1421,130,19.7484,131,19.7484,132,19.7484,133,7.07107,134,7.07107,135,7.07107,136,10,137,10,138,10,139,14.1421,140,14.1421,141,14.1421,142,22.3607,143,22.3607,144,22.3607,145,7.07107,146,7.07107,147,7.07107,148,10,149,10,150,10,151,14.1421,152,14.1421,153,14.1421,154,16.7332,155,16.7332,156,16.7332,157,7.07107,158,7.07107,159,7.07107,160,10,161,10,162,10,163,14.1421,164,14.1421,165,14.1421,166,19.7484,167,19.7484,168,19.7484,169,7.07107,170,7.07107,171,7.07107,172,10,173,10,174,10,175,14.1421,176,14.1421,177,14.1421,178,22.3607,179,22.3607,180,22.3607)
.param VSET=table(run,1,0.414832,2,0.414832,3,0.414832,4,0.611815,5,0.611815,6,0.611815,7,0.892674,8,0.892674,9,0.892674,10,1.06923,11,1.06923,12,1.06923,13,0.414832,14,0.414832,15,0.414832,16,0.611815,17,0.611815,18,0.611815,19,0.892674,20,0.892674,21,0.892674,22,1.27518,23,1.27518,24,1.27518,25,0.414832,26,0.414832,27,0.414832,28,0.611815,29,0.611815,30,0.611815,31,0.892674,32,0.892674,33,0.892674,34,1.45548,35,1.45548,36,1.45548,37,0.414832,38,0.414832,39,0.414832,40,0.611815,41,0.611815,42,0.611815,43,0.892674,44,0.892674,45,0.892674,46,1.06923,47,1.06923,48,1.06923,49,0.414832,50,0.414832,51,0.414832,52,0.611815,53,0.611815,54,0.611815,55,0.892674,56,0.892674,57,0.892674,58,1.27518,59,1.27518,60,1.27518,61,0.414832,62,0.414832,63,0.414832,64,0.611815,65,0.611815,66,0.611815,67,0.892674,68,0.892674,69,0.892674,70,1.45548,71,1.45548,72,1.45548,73,0.414832,74,0.414832,75,0.414832,76,0.611815,77,0.611815,78,0.611815,79,0.892674,80,0.892674,81,0.892674,82,1.06923,83,1.06923,84,1.06923,85,0.414832,86,0.414832,87,0.414832,88,0.611815,89,0.611815,90,0.611815,91,0.892674,92,0.892674,93,0.892674,94,1.27518,95,1.27518,96,1.27518,97,0.414832,98,0.414832,99,0.414832,100,0.611815,101,0.611815,102,0.611815,103,0.892674,104,0.892674,105,0.892674,106,1.45548,107,1.45548,108,1.45548,109,0.414832,110,0.414832,111,0.414832,112,0.611815,113,0.611815,114,0.611815,115,0.892674,116,0.892674,117,0.892674,118,1.06923,119,1.06923,120,1.06923,121,0.414832,122,0.414832,123,0.414832,124,0.611815,125,0.611815,126,0.611815,127,0.892674,128,0.892674,129,0.892674,130,1.27518,131,1.27518,132,1.27518,133,0.414832,134,0.414832,135,0.414832,136,0.611815,137,0.611815,138,0.611815,139,0.892674,140,0.892674,141,0.892674,142,1.45548,143,1.45548,144,1.45548,145,0.414832,146,0.414832,147,0.414832,148,0.611815,149,0.611815,150,0.611815,151,0.892674,152,0.892674,153,0.892674,154,1.06923,155,1.06923,156,1.06923,157,0.414832,158,0.414832,159,0.414832,160,0.611815,161,0.611815,162,0.611815,163,0.892674,164,0.892674,165,0.892674,166,1.27518,167,1.27518,168,1.27518,169,0.414832,170,0.414832,171,0.414832,172,0.611815,173,0.611815,174,0.611815,175,0.892674,176,0.892674,177,0.892674,178,1.45548,179,1.45548,180,1.45548)
.param DB=table(run,1,2.23607,2,2.23607,3,2.23607,4,2.23607,5,2.23607,6,2.23607,7,1,8,1,9,1,10,1,11,1,12,1,13,2.23607,14,2.23607,15,2.23607,16,2.23607,17,2.23607,18,2.23607,19,1,20,1,21,1,22,1,23,1,24,1,25,2.23607,26,2.23607,27,2.23607,28,2.23607,29,2.23607,30,2.23607,31,1,32,1,33,1,34,1,35,1,36,1,37,2.23607,38,2.23607,39,2.23607,40,2.23607,41,2.23607,42,2.23607,43,1,44,1,45,1,46,1,47,1,48,1,49,2.23607,50,2.23607,51,2.23607,52,2.23607,53,2.23607,54,2.23607,55,1,56,1,57,1,58,1,59,1,60,1,61,2.23607,62,2.23607,63,2.23607,64,2.23607,65,2.23607,66,2.23607,67,1,68,1,69,1,70,1,71,1,72,1,73,2.23607,74,2.23607,75,2.23607,76,2.23607,77,2.23607,78,2.23607,79,1,80,1,81,1,82,1,83,1,84,1,85,2.23607,86,2.23607,87,2.23607,88,2.23607,89,2.23607,90,2.23607,91,1,92,1,93,1,94,1,95,1,96,1,97,2.23607,98,2.23607,99,2.23607,100,2.23607,101,2.23607,102,2.23607,103,1,104,1,105,1,106,1,107,1,108,1,109,2.23607,110,2.23607,111,2.23607,112,2.23607,113,2.23607,114,2.23607,115,1,116,1,117,1,118,1,119,1,120,1,121,2.23607,122,2.23607,123,2.23607,124,2.23607,125,2.23607,126,2.23607,127,1,128,1,129,1,130,1,131,1,132,1,133,2.23607,134,2.23607,135,2.23607,136,2.23607,137,2.23607,138,2.23607,139,1,140,1,141,1,142,1,143,1,144,1,145,2.23607,146,2.23607,147,2.23607,148,2.23607,149,2.23607,150,2.23607,151,1,152,1,153,1,154,1,155,1,156,1,157,2.23607,158,2.23607,159,2.23607,160,2.23607,161,2.23607,162,2.23607,163,1,164,1,165,1,166,1,167,1,168,1,169,2.23607,170,2.23607,171,2.23607,172,2.23607,173,2.23607,174,2.23607,175,1,176,1,177,1,178,1,179,1,180,1)
.param PLEAK=1.25893e-05
.param LOSS=0.891251 KDIV=0.654 KTRIM=0.16 KFF=1.0
.step param run 1 180 1
.func tm(x) {x-TPER*floor(x/TPER)}
.func rc(u) {if(u<TLEAD,0,if(u<TLEAD+TR,0.5*(1-cos(pi*(u-TLEAD)/TR)),if(u<TLEAD+TDIT,1,if(u<TE,0.5*(1+cos(pi*(u-TLEAD-TDIT)/TR)),0))))}
.func env(x) {rc(tm(floor(x/TQ)*TQ))}
.func wnd(u,a,b) {(u>=a)*(u<b)}
.func onw(x,a,b) {max(wnd(tm(x),a,b),(x>=TPER)*wnd(tm(x)+TPER,a,b))}
V5 v5 0 5
* firmware reference: raised-cosine amplitude table predistorted by the detector law (table of
* run 2026-09-28-det-char-biased), 12-bit PWM updated every 32.768 us, 2-pole RC
* DB: detector tap factor (1, or BOOST at the 0.5 and 1 W steps of the revision 1 design)
Bref refraw 0 V=table(DB*ASET*env(time),-1,0,0,0,0.05,8.27946e-05,0.1,0.000330664,0.2,0.00131475,0.35,0.00396146,0.6,0.0111292,1,0.0278097,1.7,0.0647408,3,0.142508,5,0.270735,9,0.536205,15,0.943429,22.36,1.44789,28,1.83699)
R1 refraw r1 4.7k
C1 r1 0 10n
R2 r1 vref 4.7k
C2 vref 0 10n
* error amplifier: difference integrator about a 2.5 V mid-rail (bipolar trim), modelled as an ideal
* integrator with rails: V(out) = 2.5 V + integral of (Vref - Vdet + VOS)/(RIN*CF), limited to 0..5 V,
* reset to 2.5 V while parked; it does not load the reference or the detector (buffered inputs, e.g.
* an MCP6002 difference integrator with the spare half as buffer; WP-PDR-22 sets the circuit).
* VOS is the residual input offset after the firmware zero calibration.
* revision 1: the integrator input is opened while parked, so the trim is HELD between elements
* (no reset); it starts at mid-rail at t = 0 (power-on)
Gi 0 xi value={(1-V(park))*(V(vref)-V(detf)+VOS)/10000}
Ci xi 0 1.92e-09
Dih xi vh DI
Dil vl xi DI
Vh vh 0 2.485
Vl vl 0 -2.485
Bo out 0 V=2.5+V(xi)
.model DI D(Ron=1 Roff=1e12 Vfwd=0)
* feedforward VGG table (second 12-bit PWM, same update and 2-pole RC as the reference): the nominal
* inverse PA curve at the run's drain voltage for KFF of the wanted amplitude, 0 V when the table is 0
Bff ffraw 0 V=(env(time)>0)*max(table(10*log10(max((KFF*ASET*env(time))**2/100/LOSS/SCALE,1e-20)*1e3),-283.01,-1.8,-233.01,-1.3,-183.01,-0.8,-133.01,-0.3,-83.0103,0.2,-33.0103,0.7,16.9897,1.2,22.3045,1.3,26.0206,1.4,28.5733,1.5,30.2119,1.6,31.7609,1.7,33.0103,1.8,34.1497,1.9,35.0515,2,35.9106,2.1,36.6276,2.2,37.2428,2.3,37.4819,2.35,37.8533,2.5,38.0277,2.7,38.0956,3,38.1291,3.5,38.1624,5),0)
R3 ffraw f1 4.7k
C3 f1 0 10n
R4 f1 ff 4.7k
C4 ff 0 10n
* VGG node: feedforward plus the loop trim, KTRIM volts per volt of the error amplifier about
* mid-rail (+/-0.25 V authority), not below 0 V (Schottky clamp), 1.77 k, 10 nF
Bvt vt 0 V=max(KTRIM*(V(out)-2.5)+V(ff),0)
Rth vt vgg 1770
Cg vgg 0 1e-08
* clamps (open collector, on at reset): VGG node held low and integrator parked outside the window
* ramp start .. drive gate
Bpk park 0 V=1-onw(time,TLEAD,TE+TG)
S1 vgg 0 park 0 SWC
S4 vref 0 park 0 SWC
.model SWC SW(Ron=10 Roff=1e9 Vt=0.5 Vh=0.05)
* PA static transfer (dBm at the reference drain voltage) scaled for the drain voltage, curve shifted
* by VSH (module-to-module threshold corner)
Bpg pg 0 V=SCALE*pow(10,(table(V(vgg)-VSH,-1.8,-283.01,-1.3,-233.01,-0.8,-183.01,-0.3,-133.01,0.2,-83.0103,0.7,-33.0103,1.2,16.9897,1.3,22.3045,1.4,26.0206,1.5,28.5733,1.6,30.2119,1.7,31.7609,1.8,33.0103,1.9,34.1497,2,35.0515,2.1,35.9106,2.2,36.6276,2.3,37.2428,2.35,37.4819,2.5,37.8533,2.7,38.0277,3,38.0956,3.5,38.1291,5,38.1624)-30)/10)
* drive gate: CLK1 enable and GVA-84+ bias, 10 us
Bd dr0 0 V=onw(time,TCLK,TE+TG)
Rd dr0 dr 1k
Cd dr 0 10n
* relay pole A contact (closes 7.5 ms after the relay command)
Bc cont 0 V=time>TC
* power and amplitude at the 50 ohm load (after 0.5 dB LPF and relay loss); PLEAK is the output with
* the gate off and the exciter driven (estimate, see the record)
Bpl pl 0 V=V(cont)*V(dr)*(V(pg)+PLEAK)*LOSS
Bal al 0 V=sqrt(100*max(V(pl),0))
* detector static law from run 2026-09-28-det-char-biased and its 4.7 us video pole (10 k, 470 pF);
* DB is the tap factor (the diode sees DB times the amplitude of the 5 W design tap)
Bdet d0 0 V=table(DB*V(al),-1,0,0,0,0.05,8.27946e-05,0.1,0.000330664,0.2,0.00131475,0.35,0.00396146,0.6,0.0111292,1,0.0278097,1.7,0.0647408,3,0.142508,5,0.270735,9,0.536205,15,0.943429,22.36,1.44789,28,1.83699)
Rv d0 detf 1k
Cv detf 0 4.7n
* op-amp macro: gm stage, Aol 112 dB, GBW 1 MHz, internal node and output limited to the rails
.subckt OPA inp inn out vcc
G1 0 x inp inn 1m
Rx x 0 4e8
Cx x 0 159p
Dhi x vcc DI
Dlo 0 x DI
Bo o 0 V=limit(V(x),0.015,V(vcc)-0.015)
Ro o out 20
.model DI D(Ron=1 Roff=1e12 Vfwd=0)
.ends OPA
.save V(al) V(vgg)
.tran 0 0.384 0.0 20u
.options reltol=1e-4
.end
