* keying_a4_mitig.cir: keying envelope loop, TS-012 finalist A4 (AFT05MS004N discrete, gate-bias loop), mitigated (feedforward VGG table, loop as trim, detector predistortion, biased detector, low-pack setpoint)
* cwht WP-PDR-22 pre-order item; generated by hardware/sim/tx-keying/keying_run.py; record
* docs/design/analysis/keying-ts012.md. Envelope-domain behavioural deck (no RF carrier).
* Steps: 3, 5, 8 ms (10-90 %) at the low then the high drain voltage, for each corner in turn:
*   runs 1..6: PA curve shifted +0.0 V, error-amplifier offset +0.0 mV
*   runs 7..12: PA curve shifted -0.1 V, error-amplifier offset +0.0 mV
*   runs 13..18: PA curve shifted +0.1 V, error-amplifier offset +0.0 mV
*   runs 19..24: PA curve shifted +0.0 V, error-amplifier offset +1.0 mV
*   runs 25..30: PA curve shifted +0.0 V, error-amplifier offset -1.0 mV
* 50 WPM continuous dits: key down 24 ms, up 24 ms; relay command at key-down of element 1,
* contact closed at 7.5 ms; CLK1 and GVA-84+ bias on at 8 ms; ramp start 10 ms after each key-down;
* drive gated off 1 ms after each ramp end; VGG and integrator clamps applied at the gate.
.param TPER=0.048 TDIT=0.024 TLEAD=0.01 TCLK=0.008 TC=0.0075 TQ=3.2768e-05 TG=0.001
.param run=1
.param TSET=table(run,1,0.003,2,0.005,3,0.008,4,0.003,5,0.005,6,0.008,7,0.003,8,0.005,9,0.008,10,0.003,11,0.005,12,0.008,13,0.003,14,0.005,15,0.008,16,0.003,17,0.005,18,0.008,19,0.003,20,0.005,21,0.008,22,0.003,23,0.005,24,0.008,25,0.003,26,0.005,27,0.008,28,0.003,29,0.005,30,0.008)
.param TR={TSET/0.590334}
.param TE={TLEAD+TDIT+TR}
.param SCALE=table(run,1,0.55814,2,0.55814,3,0.55814,4,0.984132,5,0.984132,6,0.984132,7,0.55814,8,0.55814,9,0.55814,10,0.984132,11,0.984132,12,0.984132,13,0.55814,14,0.55814,15,0.55814,16,0.984132,17,0.984132,18,0.984132,19,0.55814,20,0.55814,21,0.55814,22,0.984132,23,0.984132,24,0.984132,25,0.55814,26,0.55814,27,0.55814,28,0.984132,29,0.984132,30,0.984132)
.param VSH=table(run,1,0,2,0,3,0,4,0,5,0,6,0,7,-0.1,8,-0.1,9,-0.1,10,-0.1,11,-0.1,12,-0.1,13,0.1,14,0.1,15,0.1,16,0.1,17,0.1,18,0.1,19,0,20,0,21,0,22,0,23,0,24,0,25,0,26,0,27,0,28,0,29,0,30,0)
.param VOS=table(run,1,0,2,0,3,0,4,0,5,0,6,0,7,0,8,0,9,0,10,0,11,0,12,0,13,0,14,0,15,0,16,0,17,0,18,0,19,0.001,20,0.001,21,0.001,22,0.001,23,0.001,24,0.001,25,-0.001,26,-0.001,27,-0.001,28,-0.001,29,-0.001,30,-0.001)
.param ASET=table(run,1,17.0294,2,17.0294,3,17.0294,4,22.3607,5,22.3607,6,22.3607,7,17.0294,8,17.0294,9,17.0294,10,22.3607,11,22.3607,12,22.3607,13,17.0294,14,17.0294,15,17.0294,16,22.3607,17,22.3607,18,22.3607,19,17.0294,20,17.0294,21,17.0294,22,22.3607,23,22.3607,24,22.3607,25,17.0294,26,17.0294,27,17.0294,28,22.3607,29,22.3607,30,22.3607)
.param VSET=table(run,1,1.08935,2,1.08935,3,1.08935,4,1.45548,5,1.45548,6,1.45548,7,1.08935,8,1.08935,9,1.08935,10,1.45548,11,1.45548,12,1.45548,13,1.08935,14,1.08935,15,1.08935,16,1.45548,17,1.45548,18,1.45548,19,1.08935,20,1.08935,21,1.08935,22,1.45548,23,1.45548,24,1.45548,25,1.08935,26,1.08935,27,1.08935,28,1.45548,29,1.45548,30,1.45548)
.param PLEAK=1.25893e-05
.param LOSS=0.891251 KDIV=0.654 KTRIM=0.1 KFF=1.0
.step param run 1 30 1
.func tm(x) {x-TPER*floor(x/TPER)}
.func rc(u) {if(u<TLEAD,0,if(u<TLEAD+TR,0.5*(1-cos(pi*(u-TLEAD)/TR)),if(u<TLEAD+TDIT,1,if(u<TE,0.5*(1+cos(pi*(u-TLEAD-TDIT)/TR)),0))))}
.func env(x) {rc(tm(floor(x/TQ)*TQ))}
.func wnd(u,a,b) {(u>=a)*(u<b)}
.func onw(x,a,b) {max(wnd(tm(x),a,b),(x>=TPER)*wnd(tm(x)+TPER,a,b))}
V5 v5 0 5
* firmware reference: raised-cosine amplitude table predistorted by the detector law (table of
* run 2026-09-28-det-char-biased), 12-bit PWM updated every 32.768 us, 2-pole RC
Bref refraw 0 V=table(ASET*env(time),-1,0,0,0,0.05,8.27946e-05,0.1,0.000330664,0.2,0.00131475,0.35,0.00396146,0.6,0.0111292,1,0.0278097,1.7,0.0647408,3,0.142508,5,0.270735,9,0.536205,15,0.943429,22.36,1.44789,28,1.83699)
R1 refraw r1 4.7k
C1 r1 0 10n
R2 r1 vref 4.7k
C2 vref 0 10n
* error amplifier: difference integrator about a 2.5 V mid-rail (bipolar trim), modelled as an ideal
* integrator with rails: V(out) = 2.5 V + integral of (Vref - Vdet + VOS)/(RIN*CF), limited to 0..5 V,
* reset to 2.5 V while parked; it does not load the reference or the detector (buffered inputs, e.g.
* an MCP6002 difference integrator with the spare half as buffer; WP-PDR-22 sets the circuit).
* VOS is the residual input offset after the firmware zero calibration.
Gi 0 xi value={(V(vref)-V(detf)+VOS)/10000}
Ci xi 0 1.2e-09
Dih xi vh DI
Dil vl xi DI
Vh vh 0 2.485
Vl vl 0 -2.485
S2 xi 0 park 0 SWC
Bo out 0 V=2.5+V(xi)
.model DI D(Ron=1 Roff=1e12 Vfwd=0)
* feedforward VGG table (second 12-bit PWM, same update and 2-pole RC as the reference): the nominal
* inverse PA curve at the run's drain voltage for KFF of the wanted amplitude, 0 V when the table is 0
Bff ffraw 0 V=(env(time)>0)*max(table(10*log10(max((KFF*ASET*env(time))**2/100/LOSS/SCALE,1e-20)*1e3),-283.01,-1.8,-233.01,-1.3,-183.01,-0.8,-133.01,-0.3,-83.0103,0.2,-33.0103,0.7,16.9897,1.2,22.3045,1.3,26.0206,1.4,28.5733,1.5,30.2119,1.6,31.7609,1.7,33.0103,1.8,34.1497,1.9,35.0515,2,35.9106,2.1,36.6276,2.2,37.2428,2.3,37.4819,2.35,37.8533,2.5,38.0277,2.7,38.0956,3,38.1291,3.5,38.1624,5),0)
R3 ffraw f1 4.7k
C3 f1 0 10n
R4 f1 ff 4.7k
C4 ff 0 10n
* VGG node: feedforward plus the loop trim, KTRIM volts per volt of the error amplifier about
* mid-rail (+/-0.25 V authority), not below 0 V (Schottky clamp), 1.77 k, 10 nF
Bvt vt 0 V=max(KTRIM*(V(out)-2.5)+V(ff),0)
Rth vt vgg 1770
Cg vgg 0 1e-08
* clamps (open collector, on at reset): VGG node held low and integrator parked outside the window
* ramp start .. drive gate
Bpk park 0 V=1-onw(time,TLEAD,TE+TG)
S1 vgg 0 park 0 SWC
S4 vref 0 park 0 SWC
.model SWC SW(Ron=10 Roff=1e9 Vt=0.5 Vh=0.05)
* PA static transfer (dBm at the reference drain voltage) scaled for the drain voltage, curve shifted
* by VSH (module-to-module threshold corner)
Bpg pg 0 V=SCALE*pow(10,(table(V(vgg)-VSH,-1.8,-283.01,-1.3,-233.01,-0.8,-183.01,-0.3,-133.01,0.2,-83.0103,0.7,-33.0103,1.2,16.9897,1.3,22.3045,1.4,26.0206,1.5,28.5733,1.6,30.2119,1.7,31.7609,1.8,33.0103,1.9,34.1497,2,35.0515,2.1,35.9106,2.2,36.6276,2.3,37.2428,2.35,37.4819,2.5,37.8533,2.7,38.0277,3,38.0956,3.5,38.1291,5,38.1624)-30)/10)
* drive gate: CLK1 enable and GVA-84+ bias, 10 us
Bd dr0 0 V=onw(time,TCLK,TE+TG)
Rd dr0 dr 1k
Cd dr 0 10n
* relay pole A contact (closes 7.5 ms after the relay command)
Bc cont 0 V=time>TC
* power and amplitude at the 50 ohm load (after 0.5 dB LPF and relay loss); PLEAK is the output with
* the gate off and the exciter driven (estimate, see the record)
Bpl pl 0 V=V(cont)*V(dr)*(V(pg)+PLEAK)*LOSS
Bal al 0 V=sqrt(100*max(V(pl),0))
* detector static law from run 2026-09-28-det-char-biased and its 4.7 us video pole (10 k, 470 pF)
Bdet d0 0 V=table(V(al),-1,0,0,0,0.05,8.27946e-05,0.1,0.000330664,0.2,0.00131475,0.35,0.00396146,0.6,0.0111292,1,0.0278097,1.7,0.0647408,3,0.142508,5,0.270735,9,0.536205,15,0.943429,22.36,1.44789,28,1.83699)
Rv d0 detf 1k
Cv detf 0 4.7n
* op-amp macro: gm stage, Aol 112 dB, GBW 1 MHz, internal node and output limited to the rails
.subckt OPA inp inn out vcc
G1 0 x inp inn 1m
Rx x 0 4e8
Cx x 0 159p
Dhi x vcc DI
Dlo 0 x DI
Bo o 0 V=limit(V(x),0.015,V(vcc)-0.015)
Ro o out 20
.model DI D(Ron=1 Roff=1e12 Vfwd=0)
.ends OPA
.save V(al) V(vgg) V(vref) V(detf)
.tran 0 0.384 0 20u
.options reltol=1e-4
.end
