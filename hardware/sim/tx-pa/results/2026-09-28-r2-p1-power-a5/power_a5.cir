* power_a5.cir: A5 RA07M1317M module, output power at the SMA versus pack voltage (cwht WP-PDR-21, hardware/sim/tx-pa, revision 2)
* Pack EMF Vp (swept 6.4 to 8.4 V; equal to the voltage read in receive within 10 mV) behind the drain feed rfeed;
* the 5 V bus (0.25 A, est.) and the PA drain current Pout/(eta*Vd) load the feed, so the key-down sag is solved
* by LTspice, together with the PA case temperature V(tc) of the key-down cases. V(pmod) is the PA output power in
* watts, V(psma) the power at the SMA after the output LPF and relay.
* 11664 corners flattened into one .step (idx), first dimension fastest: irf, ieta, ipin, ifr, ivgg, isp, iloss, itc.
.param idx=0
.step param idx 0 11663 1
.param irf=floor(idx/1)-3*floor(idx/3)
.param ieta=floor(idx/3)-2*floor(idx/6)
.param ipin=floor(idx/6)-3*floor(idx/18)
.param ifr=floor(idx/18)-3*floor(idx/54)
.param ivgg=floor(idx/54)-4*floor(idx/216)
.param isp=floor(idx/216)-2*floor(idx/432)
.param iloss=floor(idx/432)-3*floor(idx/1296)
.param itc=floor(idx/1296)-9*floor(idx/11664)
* temperature cases (itc): 0 25 C, start of key-down (case 25 C); 1 25 C, key-down, -0.005 dB/K; 2 25 C, key-down, -0.015 dB/K; 3 -10 C, key-down, PA no cold gain; 4 -10 C, start of key-down, PA +0.53 dB; 5 +45 C, key-down, -0.005 dB/K; 6 +45 C, key-down, -0.015 dB/K; 7 +45 C, case 100 C bound, -0.005 dB/K; 8 +45 C, case 100 C bound, -0.015 dB/K
.param rf=table(itc*3+irf,0,0.26,1,0.35,2,0.45,3,0.27562,4,0.39358,5,0.53392,6,0.27562,7,0.39358,8,0.53392,9,0.31831,10,0.45231,11,0.61301,12,0.30269,13,0.40874,14,0.52909,15,0.29294,16,0.41811,17,0.56758,18,0.29294,19,0.41811,20,0.56758,21,0.29294,22,0.41811,23,0.56758,24,0.29294,25,0.41811,26,0.56758)
* ambient (C); fixed PA case (C; -999: solved from the dissipation); PA coefficient (dB/K above 25 C);
* no gain below a 25 C case (1) or the full law (0); copper term (dB per dB of LPF loss)
.param ta=table(itc,0,25,1,25,2,25,3,-10,4,-10,5,45,6,45,7,45,8,45)
.param tcfix=table(itc,0,25,1,-999,2,-999,3,-999,4,-10,5,-999,6,-999,7,100,8,100)
.param coef=table(itc,0,-0.015,1,-0.005,2,-0.015,3,-0.015,4,-0.015,5,-0.005,6,-0.015,7,-0.005,8,-0.015)
.param ng=table(itc,0,1,1,1,2,1,3,1,4,0,5,1,6,1,7,1,8,1)
.param cu=table(itc,0,0,1,0.0858,2,0.0858,3,0.01755,4,-0.06825,5,0.1248,6,0.1248,7,0.1248,8,0.1248)
.param rth=6.11
.param pinw_pa=pow(10,(pin-30)/10)
.param pin=table(ipin,0,7.30924,1,10.5747,2,15.4962)
.param fr=table(ifr,0,1.44e+08,1,1.46e+08,2,1.48e+08)
.param loss=table(iloss,0,0.5,1,0.84,2,1.86)
.param w=(fr-135e6)/20e6
.param kloss=pow(10,-(loss+(loss-0.1)*cu)/10)
.param eta=table(ieta,0,0.45,1,0.6)
.param ivgg_=ivgg
.param isp_=isp
* drive factor: module output at pin relative to Pin 20 mW (13.01 dBm), datasheet Pout-Pin curves at 7.2 V
.param kd=((1-w)*pow(10,table(pin,-9,27.53,-8,28.52,-7,29.56,-6,30.54,-5,31.5,-4,32.56,-3,33.45,-2,34.46,-1,35.42,0,36.18,1,36.98,2,37.58,3,38.12,4,38.45,5,38.71,6,38.87,7,39.02,8,39.12,9,39.2,10,39.27,11,39.3,12,39.33,13,39.38,14,39.4,15,39.41,16,39.44)/10)+w*pow(10,table(pin,-9,27.51,-8,28.52,-7,29.52,-6,30.51,-5,31.47,-4,32.46,-3,33.38,-2,34.3,-1,35.33,0,35.98,1,36.72,2,37.35,3,37.8,4,38.15,5,38.41,6,38.59,7,38.73,8,38.82,9,38.9,10,38.95,11,39.01,12,39.08,13,39.11,14,39.17,15,39.21,16,39.24)/10))/((1-w)*pow(10,table(13.0103,-9,27.53,-8,28.52,-7,29.56,-6,30.54,-5,31.5,-4,32.56,-3,33.45,-2,34.46,-1,35.42,0,36.18,1,36.98,2,37.58,3,38.12,4,38.45,5,38.71,6,38.87,7,39.02,8,39.12,9,39.2,10,39.27,11,39.3,12,39.33,13,39.38,14,39.4,15,39.41,16,39.44)/10)+w*pow(10,table(13.0103,-9,27.51,-8,28.52,-7,29.52,-6,30.51,-5,31.47,-4,32.46,-3,33.38,-2,34.3,-1,35.33,0,35.98,1,36.72,2,37.35,3,37.8,4,38.15,5,38.41,6,38.59,7,38.73,8,38.82,9,38.9,10,38.95,11,39.01,12,39.08,13,39.11,14,39.17,15,39.21,16,39.24)/10))
* VGG factor: output at VGG 3.08, 3.27, 3.3, 3.46 V relative to 3.5 V (the Pout-VDD curve's condition),
* datasheet Pout-VGG curves at 7.2 V, Pin 20 mW (revision 2: the revision-4 clamp and the C3 lever, finding-3)
.param kv0=((1-w)*table(3.08,2.9,6.426,2.95,6.835,3,7.201,3.05,7.479,3.1,7.693,3.15,7.875,3.2,7.955,3.25,8.131,3.3,8.224,3.35,8.316,3.4,8.411,3.45,8.501,3.5,8.601,3.55,8.71,3.6,8.809)+w*table(3.08,2.9,6.185,2.95,6.594,3,7.022,3.05,7.266,3.1,7.488,3.15,7.668,3.2,7.806,3.25,7.911,3.3,7.977,3.35,8.079,3.4,8.11,3.45,8.153,3.5,8.212,3.55,8.252,3.6,8.302))/((1-w)*table(3.5,2.9,6.426,2.95,6.835,3,7.201,3.05,7.479,3.1,7.693,3.15,7.875,3.2,7.955,3.25,8.131,3.3,8.224,3.35,8.316,3.4,8.411,3.45,8.501,3.5,8.601,3.55,8.71,3.6,8.809)+w*table(3.5,2.9,6.185,2.95,6.594,3,7.022,3.05,7.266,3.1,7.488,3.15,7.668,3.2,7.806,3.25,7.911,3.3,7.977,3.35,8.079,3.4,8.11,3.45,8.153,3.5,8.212,3.55,8.252,3.6,8.302))
.param kv1=((1-w)*table(3.27,2.9,6.426,2.95,6.835,3,7.201,3.05,7.479,3.1,7.693,3.15,7.875,3.2,7.955,3.25,8.131,3.3,8.224,3.35,8.316,3.4,8.411,3.45,8.501,3.5,8.601,3.55,8.71,3.6,8.809)+w*table(3.27,2.9,6.185,2.95,6.594,3,7.022,3.05,7.266,3.1,7.488,3.15,7.668,3.2,7.806,3.25,7.911,3.3,7.977,3.35,8.079,3.4,8.11,3.45,8.153,3.5,8.212,3.55,8.252,3.6,8.302))/((1-w)*table(3.5,2.9,6.426,2.95,6.835,3,7.201,3.05,7.479,3.1,7.693,3.15,7.875,3.2,7.955,3.25,8.131,3.3,8.224,3.35,8.316,3.4,8.411,3.45,8.501,3.5,8.601,3.55,8.71,3.6,8.809)+w*table(3.5,2.9,6.185,2.95,6.594,3,7.022,3.05,7.266,3.1,7.488,3.15,7.668,3.2,7.806,3.25,7.911,3.3,7.977,3.35,8.079,3.4,8.11,3.45,8.153,3.5,8.212,3.55,8.252,3.6,8.302))
.param kv2=((1-w)*table(3.3,2.9,6.426,2.95,6.835,3,7.201,3.05,7.479,3.1,7.693,3.15,7.875,3.2,7.955,3.25,8.131,3.3,8.224,3.35,8.316,3.4,8.411,3.45,8.501,3.5,8.601,3.55,8.71,3.6,8.809)+w*table(3.3,2.9,6.185,2.95,6.594,3,7.022,3.05,7.266,3.1,7.488,3.15,7.668,3.2,7.806,3.25,7.911,3.3,7.977,3.35,8.079,3.4,8.11,3.45,8.153,3.5,8.212,3.55,8.252,3.6,8.302))/((1-w)*table(3.5,2.9,6.426,2.95,6.835,3,7.201,3.05,7.479,3.1,7.693,3.15,7.875,3.2,7.955,3.25,8.131,3.3,8.224,3.35,8.316,3.4,8.411,3.45,8.501,3.5,8.601,3.55,8.71,3.6,8.809)+w*table(3.5,2.9,6.185,2.95,6.594,3,7.022,3.05,7.266,3.1,7.488,3.15,7.668,3.2,7.806,3.25,7.911,3.3,7.977,3.35,8.079,3.4,8.11,3.45,8.153,3.5,8.212,3.55,8.252,3.6,8.302))
.param kv3=((1-w)*table(3.46,2.9,6.426,2.95,6.835,3,7.201,3.05,7.479,3.1,7.693,3.15,7.875,3.2,7.955,3.25,8.131,3.3,8.224,3.35,8.316,3.4,8.411,3.45,8.501,3.5,8.601,3.55,8.71,3.6,8.809)+w*table(3.46,2.9,6.185,2.95,6.594,3,7.022,3.05,7.266,3.1,7.488,3.15,7.668,3.2,7.806,3.25,7.911,3.3,7.977,3.35,8.079,3.4,8.11,3.45,8.153,3.5,8.212,3.55,8.252,3.6,8.302))/((1-w)*table(3.5,2.9,6.426,2.95,6.835,3,7.201,3.05,7.479,3.1,7.693,3.15,7.875,3.2,7.955,3.25,8.131,3.3,8.224,3.35,8.316,3.4,8.411,3.45,8.501,3.5,8.601,3.55,8.71,3.6,8.809)+w*table(3.5,2.9,6.185,2.95,6.594,3,7.022,3.05,7.266,3.1,7.488,3.15,7.668,3.2,7.806,3.25,7.911,3.3,7.977,3.35,8.079,3.4,8.11,3.45,8.153,3.5,8.212,3.55,8.252,3.6,8.302))
.param kv=if(ivgg_<0.5,kv0,if(ivgg_<1.5,kv1,if(ivgg_<2.5,kv2,kv3)))
* spread factor: datasheet minimum 6.5 W at 7.2 V, VGG 3.5 V, Pin 20 mW against the typical curve
.param kmin=6.5/((1-w)*table(7.2,3,1.686,3.25,1.911,3.5,2.262,3.75,2.581,4,2.933,4.25,3.285,4.5,3.664,4.75,4.132,5,4.478,5.25,4.912,5.5,5.336,5.75,5.777,6,6.358,6.25,6.745,6.5,7.248,6.75,7.733,7,8.411,7.25,8.803,7.5,9.347,7.75,9.828,8,10.57,8.25,11.03,8.5,11.58,8.75,12.2,9,12.8,9.25,13.42,9.5,13.95,9.75,14.55)+w*table(7.2,3,1.528,3.25,1.774,3.5,2.08,3.75,2.347,4,2.673,4.25,2.998,4.5,3.337,4.75,3.725,5,4.19,5.25,4.523,5.5,4.929,5.75,5.383,6,5.727,6.25,6.288,6.5,6.786,6.75,7.273,7,7.685,7.25,8.328,7.5,8.876,7.75,9.422,8,9.985,8.25,10.58,8.5,11.15,8.75,11.75,9,12.53,9.25,13.02,9.5,13.65,9.75,14.3))
.param ks=if(isp_>0.5,kmin,1)
* RA07M1317M: typical Pout versus drain voltage at Pin 20 mW, VGG 3.5 V (135 and 155 MHz, interpolated in f)
.func pv(x)=(1-w)*table(x,3,1.686,3.25,1.911,3.5,2.262,3.75,2.581,4,2.933,4.25,3.285,4.5,3.664,4.75,4.132,5,4.478,5.25,4.912,5.5,5.336,5.75,5.777,6,6.358,6.25,6.745,6.5,7.248,6.75,7.733,7,8.411,7.25,8.803,7.5,9.347,7.75,9.828,8,10.57,8.25,11.03,8.5,11.58,8.75,12.2,9,12.8,9.25,13.42,9.5,13.95,9.75,14.55)+w*table(x,3,1.528,3.25,1.774,3.5,2.08,3.75,2.347,4,2.673,4.25,2.998,4.5,3.337,4.75,3.725,5,4.19,5.25,4.523,5.5,4.929,5.75,5.383,6,5.727,6.25,6.288,6.5,6.786,6.75,7.273,7,7.685,7.25,8.328,7.5,8.876,7.75,9.422,8,9.985,8.25,10.58,8.5,11.15,8.75,11.75,9,12.53,9.25,13.02,9.5,13.65,9.75,14.3)
* PA case temperature: fixed, or ambient plus Rth_ca times the PA dissipation Pout (1/eta - 1) + Pin (WP-PDR-28)
Btc tc 0 V=if(tcfix>-500,tcfix,ta+rth*(V(pmod)*(1/eta-1)+pinw_pa))
Rtc tc 0 1meg
.func kt(t)=pow(10,coef*if(ng>0.5,max(t-25,0),t-25)/10)
Bmod pmod 0 V=pv(max(V(d),3))*kd*kv*ks*kt(V(tc))
Rmod pmod 0 1meg
Bpa d 0 I=V(pmod)/(eta*max(V(d),1))
Vp p 0 7.4
Rf p d {rf}
Ibus d 0 0.25
Bsma psma 0 V=V(pmod)*kloss
Rsma psma 0 1meg
.dc Vp 6.4 8.4 0.05
.save V(d) V(pmod) V(psma) V(tc) I(Vp)
.end
