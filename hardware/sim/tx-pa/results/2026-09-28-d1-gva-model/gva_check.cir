* gva_check.cir: GVA-84+ behavioural model check (cwht WP-PDR-21, hardware/sim/tx-pa, run 2026-09-28-d1-gva-model)
* A 146 MHz sine of available power pin (dBm) from a 50 ohm source drives the model: 50 ohm input, Rapp
* limiter on the instantaneous voltage (p = 2.7046, Vsat per P1dB set), 50 ohm source resistance, 50 ohm load.
* Gain 24.1 dB (datasheet typ at 0.1 GHz). The checker reads the fundamental at the load by DFT of the .raw and
* compares the 1 dB and 3 dB compression points with the datasheet (Rev. F: P1dB +20.4 typ / +19.4 min dBm,
* Psat at 3 dB compression +21.7 typ dBm) and the est. high set (+21.4 / +22.7 dBm).
.param pin=-20
.param iv=1
.step param pin -20 4 1
.step param iv 0 2 1
.param vsat=table(iv,0,2.9921,1,3.3572,2,3.7669)
.param G=pow(10,24.1/20)
.param p=2.7046
V1 src 0 SIN(0 {sqrt(8*50*1e-3*pow(10,pin/10))} 146Meg)
Rs src gin 50
Rgin gin 0 50
Bg gs 0 V=2*{G}*V(gin)/pow(1+pow(abs({G}*V(gin))/{vsat},2*{p}),1/(2*{p}))
Rgo gs gout 50
Rl gout 0 50
.tran 0 60n 39n 5p
.options plotwinsize=0
.save V(gin) V(gout)
.end
