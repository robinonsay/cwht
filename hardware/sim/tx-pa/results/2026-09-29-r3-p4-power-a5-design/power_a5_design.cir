* power_a5_design.cir: A5 RA07M1317M, output power at the SMA versus pack voltage with the adopted design
* (cwht WP-PDR-21 revision 3, hardware/sim/tx-pa/run_a5_r3.py p4; record docs/design/analysis/pa-drive-ts012.md)
* As revision 2 (power_a5.cir) with: the drive band of the select-on-test pad on the bandpass chain (s2); the D-9
* pack-dependent VGG clamp, VGG(Vp) = top(Vp) + offset, top(Vp) the most generous clamp that holds the open-loop ceiling:
* at each 0.1 V the VGG at which the highest corner from a -10 C start makes 7.9 W, capped at 3.5 V (3.500 V at
* 6.4 V, 2.8588 V at 8.4 V); offsets -0.2, -0.1, 0 V;
* the drain feed from the datasheet reads per part and temperature case; the D-14 LPF loss corners [0.84, 1.03, 1.34, 1.86] dB.
* 15552 corners flattened into one .step (idx), first dimension fastest: irf, ieta, ipin, ifr, ivgg, isp, iloss, itc.
.param idx=0
.step param idx 0 15551 1
.param irf=floor(idx/1)-4*floor(idx/4)
.param ieta=floor(idx/4)-2*floor(idx/8)
.param ipin=floor(idx/8)-3*floor(idx/24)
.param ifr=floor(idx/24)-3*floor(idx/72)
.param ivgg=floor(idx/72)-3*floor(idx/216)
.param isp=floor(idx/216)-2*floor(idx/432)
.param iloss=floor(idx/432)-4*floor(idx/1728)
.param itc=floor(idx/1728)-9*floor(idx/15552)
* temperature cases (itc): 0 25 C, start of key-down (case 25 C); 1 25 C, key-down, -0.005 dB/K; 2 25 C, key-down, -0.015 dB/K; 3 -10 C, key-down, PA no cold gain; 4 -10 C, start of key-down, PA +0.53 dB; 5 +45 C, key-down, -0.005 dB/K; 6 +45 C, key-down, -0.015 dB/K; 7 +45 C, case 100 C bound, -0.005 dB/K; 8 +45 C, case 100 C bound, -0.015 dB/K
.param rf=table(itc*4+irf,0,0.238,1,0.345,2,0.452,3,0.314,4,0.24954,5,0.38312,6,0.5324,7,0.36404,8,0.24954,9,0.38312,10,0.5324,11,0.36404,12,0.3033,13,0.44951,14,0.61396,15,0.46685,16,0.29291,17,0.4149,18,0.53841,19,0.41828,20,0.26142,21,0.40427,22,0.56465,23,0.38414,24,0.26142,25,0.40427,26,0.56465,27,0.38414,28,0.26142,29,0.40427,30,0.56465,31,0.38414,32,0.26142,33,0.40427,34,0.56465,35,0.38414)
.param ta=table(itc,0,25,1,25,2,25,3,-10,4,-10,5,45,6,45,7,45,8,45)
.param tcfix=table(itc,0,25,1,-999,2,-999,3,-999,4,-10,5,-999,6,-999,7,100,8,100)
.param coef=table(itc,0,-0.015,1,-0.005,2,-0.015,3,-0.015,4,-0.015,5,-0.005,6,-0.015,7,-0.005,8,-0.015)
.param ng=table(itc,0,1,1,1,2,1,3,1,4,0,5,1,6,1,7,1,8,1)
.param cu=table(itc,0,0,1,0.0858,2,0.0858,3,0.01755,4,-0.06825,5,0.1248,6,0.1248,7,0.1248,8,0.1248)
.param rth=6.11
.param pinw_pa=pow(10,(pin-30)/10)
.param pin=table(ipin,0,10.4025,1,12.3805,2,14.3584)
.param fr=table(ifr,0,1.44e+08,1,1.46e+08,2,1.48e+08)
.param loss=table(iloss,0,0.84,1,1.03,2,1.34,3,1.86)
.param vgg=table(ivgg,0,-0.2,1,-0.1,2,0)
.param eta=table(ieta,0,0.45,1,0.6)
.param w=(fr-135e6)/20e6
.param kloss=pow(10,-(loss+(loss-0.1)*cu)/10)
.param isp_=isp
* drive factor: datasheet Pout-Pin curves at 7.2 V, relative to Pin 20 mW
.param kd=((1-w)*pow(10,table(pin,-9,27.53,-8,28.52,-7,29.56,-6,30.54,-5,31.5,-4,32.56,-3,33.45,-2,34.46,-1,35.42,0,36.18,1,36.98,2,37.58,3,38.12,4,38.45,5,38.71,6,38.87,7,39.02,8,39.12,9,39.2,10,39.27,11,39.3,12,39.33,13,39.38,14,39.4,15,39.41,16,39.44)/10)+w*pow(10,table(pin,-9,27.51,-8,28.52,-7,29.52,-6,30.51,-5,31.47,-4,32.46,-3,33.38,-2,34.3,-1,35.33,0,35.98,1,36.72,2,37.35,3,37.8,4,38.15,5,38.41,6,38.59,7,38.73,8,38.82,9,38.9,10,38.95,11,39.01,12,39.08,13,39.11,14,39.17,15,39.21,16,39.24)/10))/((1-w)*pow(10,table(13.0103,-9,27.53,-8,28.52,-7,29.56,-6,30.54,-5,31.5,-4,32.56,-3,33.45,-2,34.46,-1,35.42,0,36.18,1,36.98,2,37.58,3,38.12,4,38.45,5,38.71,6,38.87,7,39.02,8,39.12,9,39.2,10,39.27,11,39.3,12,39.33,13,39.38,14,39.4,15,39.41,16,39.44)/10)+w*pow(10,table(13.0103,-9,27.51,-8,28.52,-7,29.52,-6,30.51,-5,31.47,-4,32.46,-3,33.38,-2,34.3,-1,35.33,0,35.98,1,36.72,2,37.35,3,37.8,4,38.15,5,38.41,6,38.59,7,38.73,8,38.82,9,38.9,10,38.95,11,39.01,12,39.08,13,39.11,14,39.17,15,39.21,16,39.24)/10))
* spread factor: datasheet minimum 6.5 W at 7.2 V against the typical curve
.param kmin=6.5/((1-w)*table(7.2,3,1.686,3.25,1.911,3.5,2.262,3.75,2.581,4,2.933,4.25,3.285,4.5,3.664,4.75,4.132,5,4.478,5.25,4.912,5.5,5.336,5.75,5.777,6,6.358,6.25,6.745,6.5,7.248,6.75,7.733,7,8.411,7.25,8.803,7.5,9.347,7.75,9.828,8,10.57,8.25,11.03,8.5,11.58,8.75,12.2,9,12.8,9.25,13.42,9.5,13.95,9.75,14.55)+w*table(7.2,3,1.528,3.25,1.774,3.5,2.08,3.75,2.347,4,2.673,4.25,2.998,4.5,3.337,4.75,3.725,5,4.19,5.25,4.523,5.5,4.929,5.75,5.383,6,5.727,6.25,6.288,6.5,6.786,6.75,7.273,7,7.685,7.25,8.328,7.5,8.876,7.75,9.422,8,9.985,8.25,10.58,8.5,11.15,8.75,11.75,9,12.53,9.25,13.02,9.5,13.65,9.75,14.3))
.param ks=if(isp_>0.5,kmin,1)
.func pv(x)=(1-w)*table(x,3,1.686,3.25,1.911,3.5,2.262,3.75,2.581,4,2.933,4.25,3.285,4.5,3.664,4.75,4.132,5,4.478,5.25,4.912,5.5,5.336,5.75,5.777,6,6.358,6.25,6.745,6.5,7.248,6.75,7.733,7,8.411,7.25,8.803,7.5,9.347,7.75,9.828,8,10.57,8.25,11.03,8.5,11.58,8.75,12.2,9,12.8,9.25,13.42,9.5,13.95,9.75,14.55)+w*table(x,3,1.528,3.25,1.774,3.5,2.08,3.75,2.347,4,2.673,4.25,2.998,4.5,3.337,4.75,3.725,5,4.19,5.25,4.523,5.5,4.929,5.75,5.383,6,5.727,6.25,6.288,6.5,6.786,6.75,7.273,7,7.685,7.25,8.328,7.5,8.876,7.75,9.422,8,9.985,8.25,10.58,8.5,11.15,8.75,11.75,9,12.53,9.25,13.02,9.5,13.65,9.75,14.3)
* D-9 clamp: VGG as a function of the pack voltage V(p) (read in receive; the clamp divider is fed from the pack)
.func vggof(x)=table(x,6.4,3.5,6.5,3.5,6.6,3.5,6.7,3.5,6.8,3.5,6.9,3.5,7,3.5,7.1,3.5,7.2,3.3551,7.3,3.2309,7.4,3.1407,7.5,3.0786,7.6,3.0304,7.7,2.995,7.8,2.9715,7.9,2.9485,8,2.9272,8.1,2.9072,8.2,2.8908,8.3,2.8761,8.4,2.8588)+vgg
.func gv(x)=(1-w)*table(x,2.4,0.3275,2.45,0.6046,2.5,1.007,2.55,1.471,2.6,2.174,2.65,2.954,2.7,3.793,2.75,4.687,2.8,5.367,2.85,5.932,2.9,6.426,2.95,6.845,3,7.201,3.05,7.479,3.1,7.693,3.15,7.879,3.2,7.955,3.25,8.131,3.3,8.224,3.35,8.316,3.4,8.411,3.45,8.501,3.5,8.607,3.55,8.71,3.6,8.809)+w*table(x,2.4,0.3968,2.45,0.6761,2.5,1.109,2.55,1.544,2.6,2.247,2.65,2.91,2.7,3.686,2.75,4.511,2.8,5.146,2.85,5.716,2.9,6.185,2.95,6.594,3,7.022,3.05,7.266,3.1,7.488,3.15,7.668,3.2,7.806,3.25,7.911,3.3,7.977,3.35,8.079,3.4,8.11,3.45,8.153,3.5,8.212,3.55,8.252,3.6,8.302)
.param gref=(1-w)*table(3.5,2.4,0.3275,2.45,0.6046,2.5,1.007,2.55,1.471,2.6,2.174,2.65,2.954,2.7,3.793,2.75,4.687,2.8,5.367,2.85,5.932,2.9,6.426,2.95,6.845,3,7.201,3.05,7.479,3.1,7.693,3.15,7.879,3.2,7.955,3.25,8.131,3.3,8.224,3.35,8.316,3.4,8.411,3.45,8.501,3.5,8.607,3.55,8.71,3.6,8.809)+w*table(3.5,2.4,0.3968,2.45,0.6761,2.5,1.109,2.55,1.544,2.6,2.247,2.65,2.91,2.7,3.686,2.75,4.511,2.8,5.146,2.85,5.716,2.9,6.185,2.95,6.594,3,7.022,3.05,7.266,3.1,7.488,3.15,7.668,3.2,7.806,3.25,7.911,3.3,7.977,3.35,8.079,3.4,8.11,3.45,8.153,3.5,8.212,3.55,8.252,3.6,8.302)
Btc tc 0 V=if(tcfix>-500,tcfix,ta+rth*(V(pmod)*(1/eta-1)+pinw_pa))
Rtc tc 0 1meg
.func kt(t)=pow(10,coef*if(ng>0.5,max(t-25,0),t-25)/10)
Bvg vg 0 V=vggof(V(p))
Rvg vg 0 1meg
Bmod pmod 0 V=pv(max(V(d),3))*kd*gv(V(vg))/gref*ks*kt(V(tc))
Rmod pmod 0 1meg
Bpa d 0 I=V(pmod)/(eta*max(V(d),1))
Vp p 0 7.4
Rf p d {rf}
Ibus d 0 0.25
Bsma psma 0 V=V(pmod)*kloss
Rsma psma 0 1meg
.dc Vp 6.4 8.4 0.05
.save V(d) V(pmod) V(psma) V(tc) V(vg) I(Vp)
.end
