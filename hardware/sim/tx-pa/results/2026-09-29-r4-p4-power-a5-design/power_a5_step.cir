* power_a5_step.cir: A5 RA07M1317M, output power at the SMA versus pack voltage, per-unit clamp step (revision 4)
* (cwht WP-PDR-21 revision 4, hardware/sim/tx-pa/run_a5_r4.py p4; record docs/design/analysis/pa-drive-ts012.md section R4)
* As revision 3 (power_a5_design.cir) with: the drive band of r4-s2 (10.99, 18.20, 27.37 mW);
* the clamp top set per unit by the build step: VGG(Vp) = top(Vp) + offset, top(Vp) the VGG at which the unit the step
* believes (base, spread ua = ux + e dB) makes tgt = 6.2934 W at its highest open-loop case (-10 C start and 25 C
* start, each of 144, 146, 148 MHz, the unit's own feed, efficiency and drive), capped at 3.50 V; closed form below.
* tgt = 7.9 W x 10^(-g-/10) for the 8 W ceiling. Offsets -0.2, -0.1, 0 V.
* Unit cases (iu): 0 typical, read exactly (x +0.000, e +0.000 dB); 1 typical, read high by the bound (x +0.000, e +0.889 dB); 2 typical, read low by the bound (x +0.000, e -0.987 dB); 3 +1.5 dB (trim-range top), read high (x +1.500, e +0.889 dB); 4 +1.5 dB (trim-range top), read low (x +1.500, e -0.987 dB); 5 datasheet minimum, read high (x +0.000, e +0.889 dB); 6 datasheet minimum, read low (x +0.000, e -0.987 dB).
* The output loss (LPF plus relay, [0.84, 1.03, 1.34, 1.86] dB, with the copper term cu per temperature case) scales the module output only:
* the checker applies it to V(pmod) (power at the SMA = V(pmod) x 10^(-(loss + (loss - 0.1) cu)/10)), as revision 3's Bsma did.
* 13608 corners flattened into one .step (idx), first dimension fastest: irf, ieta, ipin, ifr, ivgg, iu, itc.
.param idx=0
.step param idx 0 13607 1
.param irf=floor(idx/1)-4*floor(idx/4)
.param ieta=floor(idx/4)-2*floor(idx/8)
.param ipin=floor(idx/8)-3*floor(idx/24)
.param ifr=floor(idx/24)-3*floor(idx/72)
.param ivgg=floor(idx/72)-3*floor(idx/216)
.param iu=floor(idx/216)-7*floor(idx/1512)
.param itc=floor(idx/1512)-9*floor(idx/13608)
* temperature cases (itc): 0 25 C, start of key-down (case 25 C); 1 25 C, key-down, -0.005 dB/K; 2 25 C, key-down, -0.015 dB/K; 3 -10 C, key-down, PA no cold gain; 4 -10 C, start of key-down, PA +0.53 dB; 5 +45 C, key-down, -0.005 dB/K; 6 +45 C, key-down, -0.015 dB/K; 7 +45 C, case 100 C bound, -0.005 dB/K; 8 +45 C, case 100 C bound, -0.015 dB/K
.param rf=table(itc*4+irf,0,0.238,1,0.345,2,0.452,3,0.314,4,0.24954,5,0.38312,6,0.5324,7,0.36404,8,0.24954,9,0.38312,10,0.5324,11,0.36404,12,0.3033,13,0.44951,14,0.61396,15,0.46685,16,0.29291,17,0.4149,18,0.53841,19,0.41828,20,0.26142,21,0.40427,22,0.56465,23,0.38414,24,0.26142,25,0.40427,26,0.56465,27,0.38414,28,0.26142,29,0.40427,30,0.56465,31,0.38414,32,0.26142,33,0.40427,34,0.56465,35,0.38414)
.param rfc=table(irf,0,0.29291,1,0.4149,2,0.53841,3,0.41828)
.param rfs=table(irf,0,0.238,1,0.345,2,0.452,3,0.314)
.param ta=table(itc,0,25,1,25,2,25,3,-10,4,-10,5,45,6,45,7,45,8,45)
.param tcfix=table(itc,0,25,1,-999,2,-999,3,-999,4,-10,5,-999,6,-999,7,100,8,100)
.param coef=table(itc,0,-0.015,1,-0.005,2,-0.015,3,-0.015,4,-0.015,5,-0.005,6,-0.015,7,-0.005,8,-0.015)
.param ng=table(itc,0,1,1,1,2,1,3,1,4,0,5,1,6,1,7,1,8,1)
.param cu=table(itc,0,0,1,0.0858,2,0.0858,3,0.01755,4,-0.06825,5,0.1248,6,0.1248,7,0.1248,8,0.1248)
.param rth=6.11
.param pinw_pa=pow(10,(pin-30)/10)
.param pin=table(ipin,0,10.4114,1,12.6007,2,14.3731)
.param fr=table(ifr,0,1.44e+08,1,1.46e+08,2,1.48e+08)
.param vgg=table(ivgg,0,-0.2,1,-0.1,2,0)
.param eta=table(ieta,0,0.45,1,0.6)
.param ubase=table(iu,0,0,1,0,2,0,3,0,4,0,5,1,6,1)
.param ux=table(iu,0,0,1,0,2,0,3,1.5,4,1.5,5,0,6,0)
.param ua=table(iu,0,0,1,0.888583,2,-0.987416,3,2.38858,4,0.512584,5,0.888583,6,-0.987416)
.param tgt=6.2934
.param ktc=1.1285
.param kts=1
.param w=(fr-135e6)/20e6
* drive factor: datasheet Pout-Pin curves at 7.2 V, relative to Pin 20 mW
.param kd=((1-w)*pow(10,table(pin,-9,27.53024,-8,28.52487,-7,29.56041,-6,30.53932,-5,31.50239,-4,32.55712,-3,33.45262,-2,34.46404,-1,35.41936,0,36.17981,1,36.97917,2,37.58065,3,38.12332,4,38.45094,5,38.70671,6,38.87432,7,39.01805,8,39.12131,9,39.19688,10,39.26613,11,39.30278,12,39.32968,13,39.3817,14,39.40356,15,39.41159,16,39.4355)/10)+w*pow(10,table(pin,-9,27.50504,-8,28.51815,-7,29.52088,-6,30.51412,-5,31.46654,-4,32.458,-3,33.38038,-2,34.30107,-1,35.33453,0,35.9797,1,36.71538,2,37.34542,3,37.80242,4,38.15356,5,38.41098,6,38.59377,7,38.72552,8,38.82224,9,38.89948,10,38.9516,11,39.01381,12,39.08264,13,39.11448,14,39.1667,15,39.20844,16,39.24058)/10))/((1-w)*pow(10,table(13.0103,-9,27.53024,-8,28.52487,-7,29.56041,-6,30.53932,-5,31.50239,-4,32.55712,-3,33.45262,-2,34.46404,-1,35.41936,0,36.17981,1,36.97917,2,37.58065,3,38.12332,4,38.45094,5,38.70671,6,38.87432,7,39.01805,8,39.12131,9,39.19688,10,39.26613,11,39.30278,12,39.32968,13,39.3817,14,39.40356,15,39.41159,16,39.4355)/10)+w*pow(10,table(13.0103,-9,27.50504,-8,28.51815,-7,29.52088,-6,30.51412,-5,31.46654,-4,32.458,-3,33.38038,-2,34.30107,-1,35.33453,0,35.9797,1,36.71538,2,37.34542,3,37.80242,4,38.15356,5,38.41098,6,38.59377,7,38.72552,8,38.82224,9,38.89948,10,38.9516,11,39.01381,12,39.08264,13,39.11448,14,39.1667,15,39.20844,16,39.24058)/10))
* spread factor of the true unit: typical curve, or datasheet minimum 6.5 W at 7.2 V, times 10^(ux/10)
.param kmin=6.5/((1-w)*table(7.2,3,1.68635,3.25,1.911414,3.5,2.26155,3.75,2.581005,4,2.932957,4.25,3.284919,4.5,3.664267,4.75,4.13185,5,4.478057,5.25,4.912471,5.5,5.335995,5.75,5.776537,6,6.357533,6.25,6.744881,6.5,7.2484,6.75,7.733295,7,8.41118,7.25,8.803405,7.5,9.347171,7.75,9.828414,8,10.57303,8.25,11.03219,8.5,11.57701,8.75,12.2044,9,12.79627,9.25,13.41899,9.5,13.95344,9.75,14.54642)+w*table(7.2,3,1.528336,3.25,1.773871,3.5,2.08044,3.75,2.3469,4,2.672786,4.25,2.998138,4.5,3.337052,4.75,3.724933,5,4.189925,5.25,4.523014,5.5,4.928967,5.75,5.382814,6,5.727043,6.25,6.287843,6.5,6.785595,6.75,7.272676,7,7.68492,7.25,8.328276,7.5,8.875771,7.75,9.421652,8,9.985392,8.25,10.57781,8.5,11.14978,8.75,11.7455,9,12.52763,9.25,13.02421,9.5,13.65151,9.75,14.29609))
.param ks=if(ubase>0.5,kmin,1)*pow(10,ux/10)
.func pv(x)=(1-w)*table(x,3,1.68635,3.25,1.911414,3.5,2.26155,3.75,2.581005,4,2.932957,4.25,3.284919,4.5,3.664267,4.75,4.13185,5,4.478057,5.25,4.912471,5.5,5.335995,5.75,5.776537,6,6.357533,6.25,6.744881,6.5,7.2484,6.75,7.733295,7,8.41118,7.25,8.803405,7.5,9.347171,7.75,9.828414,8,10.57303,8.25,11.03219,8.5,11.57701,8.75,12.2044,9,12.79627,9.25,13.41899,9.5,13.95344,9.75,14.54642)+w*table(x,3,1.528336,3.25,1.773871,3.5,2.08044,3.75,2.3469,4,2.672786,4.25,2.998138,4.5,3.337052,4.75,3.724933,5,4.189925,5.25,4.523014,5.5,4.928967,5.75,5.382814,6,5.727043,6.25,6.287843,6.5,6.785595,6.75,7.272676,7,7.68492,7.25,8.328276,7.5,8.875771,7.75,9.421652,8,9.985392,8.25,10.57781,8.5,11.14978,8.75,11.7455,9,12.52763,9.25,13.02421,9.5,13.65151,9.75,14.29609)
.func gv(x)=(1-w)*table(x,2.3,0.07439167,2.35,0.1612167,2.4,0.3275167,2.45,0.6046385,2.5,1.00654,2.55,1.471175,2.6,2.173817,2.65,2.953775,2.7,3.793117,2.75,4.687342,2.8,5.366515,2.85,5.931745,2.9,6.425925,2.95,6.844508,3,7.20136,3.05,7.479142,3.1,7.692775,3.15,7.879375,3.2,7.9549,3.25,8.130767,3.3,8.224446,3.35,8.315675,3.4,8.410942,3.45,8.501133,3.5,8.60696,3.55,8.709692,3.6,8.809467)+w*table(x,2.3,0.09723333,2.35,0.202375,2.4,0.3968417,2.45,0.6760917,2.5,1.10944,2.55,1.544383,2.6,2.247058,2.65,2.910117,2.7,3.6857,2.75,4.51095,2.8,5.145558,2.85,5.716233,2.9,6.184775,2.95,6.594117,3,7.02228,3.05,7.265692,3.1,7.487842,3.15,7.6676,3.2,7.805558,3.25,7.910683,3.3,7.977352,3.35,8.0791,3.4,8.110438,3.45,8.153192,3.5,8.21208,3.55,8.251838,3.6,8.302433)
.param gref=(1-w)*table(3.5,2.3,0.07439167,2.35,0.1612167,2.4,0.3275167,2.45,0.6046385,2.5,1.00654,2.55,1.471175,2.6,2.173817,2.65,2.953775,2.7,3.793117,2.75,4.687342,2.8,5.366515,2.85,5.931745,2.9,6.425925,2.95,6.844508,3,7.20136,3.05,7.479142,3.1,7.692775,3.15,7.879375,3.2,7.9549,3.25,8.130767,3.3,8.224446,3.35,8.315675,3.4,8.410942,3.45,8.501133,3.5,8.60696,3.55,8.709692,3.6,8.809467)+w*table(3.5,2.3,0.09723333,2.35,0.202375,2.4,0.3968417,2.45,0.6760917,2.5,1.10944,2.55,1.544383,2.6,2.247058,2.65,2.910117,2.7,3.6857,2.75,4.51095,2.8,5.145558,2.85,5.716233,2.9,6.184775,2.95,6.594117,3,7.02228,3.05,7.265692,3.1,7.487842,3.15,7.6676,3.2,7.805558,3.25,7.910683,3.3,7.977352,3.35,8.0791,3.4,8.110438,3.45,8.153192,3.5,8.21208,3.55,8.251838,3.6,8.302433)
* per-unit clamp (the build step): per frequency, the believed unit's drive factor, spread factor and inverse VGG curve
.param kd144=((1-0.45)*pow(10,table(pin,-9,27.53024,-8,28.52487,-7,29.56041,-6,30.53932,-5,31.50239,-4,32.55712,-3,33.45262,-2,34.46404,-1,35.41936,0,36.17981,1,36.97917,2,37.58065,3,38.12332,4,38.45094,5,38.70671,6,38.87432,7,39.01805,8,39.12131,9,39.19688,10,39.26613,11,39.30278,12,39.32968,13,39.3817,14,39.40356,15,39.41159,16,39.4355)/10)+0.45*pow(10,table(pin,-9,27.50504,-8,28.51815,-7,29.52088,-6,30.51412,-5,31.46654,-4,32.458,-3,33.38038,-2,34.30107,-1,35.33453,0,35.9797,1,36.71538,2,37.34542,3,37.80242,4,38.15356,5,38.41098,6,38.59377,7,38.72552,8,38.82224,9,38.89948,10,38.9516,11,39.01381,12,39.08264,13,39.11448,14,39.1667,15,39.20844,16,39.24058)/10))/((1-0.45)*pow(10,table(13.0103,-9,27.53024,-8,28.52487,-7,29.56041,-6,30.53932,-5,31.50239,-4,32.55712,-3,33.45262,-2,34.46404,-1,35.41936,0,36.17981,1,36.97917,2,37.58065,3,38.12332,4,38.45094,5,38.70671,6,38.87432,7,39.01805,8,39.12131,9,39.19688,10,39.26613,11,39.30278,12,39.32968,13,39.3817,14,39.40356,15,39.41159,16,39.4355)/10)+0.45*pow(10,table(13.0103,-9,27.50504,-8,28.51815,-7,29.52088,-6,30.51412,-5,31.46654,-4,32.458,-3,33.38038,-2,34.30107,-1,35.33453,0,35.9797,1,36.71538,2,37.34542,3,37.80242,4,38.15356,5,38.41098,6,38.59377,7,38.72552,8,38.82224,9,38.89948,10,38.9516,11,39.01381,12,39.08264,13,39.11448,14,39.1667,15,39.20844,16,39.24058)/10))
.param kd146=((1-0.55)*pow(10,table(pin,-9,27.53024,-8,28.52487,-7,29.56041,-6,30.53932,-5,31.50239,-4,32.55712,-3,33.45262,-2,34.46404,-1,35.41936,0,36.17981,1,36.97917,2,37.58065,3,38.12332,4,38.45094,5,38.70671,6,38.87432,7,39.01805,8,39.12131,9,39.19688,10,39.26613,11,39.30278,12,39.32968,13,39.3817,14,39.40356,15,39.41159,16,39.4355)/10)+0.55*pow(10,table(pin,-9,27.50504,-8,28.51815,-7,29.52088,-6,30.51412,-5,31.46654,-4,32.458,-3,33.38038,-2,34.30107,-1,35.33453,0,35.9797,1,36.71538,2,37.34542,3,37.80242,4,38.15356,5,38.41098,6,38.59377,7,38.72552,8,38.82224,9,38.89948,10,38.9516,11,39.01381,12,39.08264,13,39.11448,14,39.1667,15,39.20844,16,39.24058)/10))/((1-0.55)*pow(10,table(13.0103,-9,27.53024,-8,28.52487,-7,29.56041,-6,30.53932,-5,31.50239,-4,32.55712,-3,33.45262,-2,34.46404,-1,35.41936,0,36.17981,1,36.97917,2,37.58065,3,38.12332,4,38.45094,5,38.70671,6,38.87432,7,39.01805,8,39.12131,9,39.19688,10,39.26613,11,39.30278,12,39.32968,13,39.3817,14,39.40356,15,39.41159,16,39.4355)/10)+0.55*pow(10,table(13.0103,-9,27.50504,-8,28.51815,-7,29.52088,-6,30.51412,-5,31.46654,-4,32.458,-3,33.38038,-2,34.30107,-1,35.33453,0,35.9797,1,36.71538,2,37.34542,3,37.80242,4,38.15356,5,38.41098,6,38.59377,7,38.72552,8,38.82224,9,38.89948,10,38.9516,11,39.01381,12,39.08264,13,39.11448,14,39.1667,15,39.20844,16,39.24058)/10))
.param kd148=((1-0.65)*pow(10,table(pin,-9,27.53024,-8,28.52487,-7,29.56041,-6,30.53932,-5,31.50239,-4,32.55712,-3,33.45262,-2,34.46404,-1,35.41936,0,36.17981,1,36.97917,2,37.58065,3,38.12332,4,38.45094,5,38.70671,6,38.87432,7,39.01805,8,39.12131,9,39.19688,10,39.26613,11,39.30278,12,39.32968,13,39.3817,14,39.40356,15,39.41159,16,39.4355)/10)+0.65*pow(10,table(pin,-9,27.50504,-8,28.51815,-7,29.52088,-6,30.51412,-5,31.46654,-4,32.458,-3,33.38038,-2,34.30107,-1,35.33453,0,35.9797,1,36.71538,2,37.34542,3,37.80242,4,38.15356,5,38.41098,6,38.59377,7,38.72552,8,38.82224,9,38.89948,10,38.9516,11,39.01381,12,39.08264,13,39.11448,14,39.1667,15,39.20844,16,39.24058)/10))/((1-0.65)*pow(10,table(13.0103,-9,27.53024,-8,28.52487,-7,29.56041,-6,30.53932,-5,31.50239,-4,32.55712,-3,33.45262,-2,34.46404,-1,35.41936,0,36.17981,1,36.97917,2,37.58065,3,38.12332,4,38.45094,5,38.70671,6,38.87432,7,39.01805,8,39.12131,9,39.19688,10,39.26613,11,39.30278,12,39.32968,13,39.3817,14,39.40356,15,39.41159,16,39.4355)/10)+0.65*pow(10,table(13.0103,-9,27.50504,-8,28.51815,-7,29.52088,-6,30.51412,-5,31.46654,-4,32.458,-3,33.38038,-2,34.30107,-1,35.33453,0,35.9797,1,36.71538,2,37.34542,3,37.80242,4,38.15356,5,38.41098,6,38.59377,7,38.72552,8,38.82224,9,38.89948,10,38.9516,11,39.01381,12,39.08264,13,39.11448,14,39.1667,15,39.20844,16,39.24058)/10))
.param ksa144=if(ubase>0.5,0.765737,1)*pow(10,ua/10)
.param ksa146=if(ubase>0.5,0.770506,1)*pow(10,ua/10)
.param ksa148=if(ubase>0.5,0.775334,1)*pow(10,ua/10)
.func inv144(y)=table(y,0.0100448,2.3,0.0213231,2.35,0.0425557,2.4,0.0755454,2.45,0.124904,2.5,0.17844,2.55,0.261799,2.6,0.348088,2.65,0.444259,2.7,0.546663,2.75,0.624857,2.8,0.692203,2.85,0.749461,2.9,0.798626,2.95,0.844768,3,0.875888,3.05,0.901687,3.1,0.923459,3.15,0.935751,3.2,0.952839,3.25,0.96251,3.3,0.973895,3.35,0.981784,3.4,0.989951,3.45,1,3.5,1.00883,3.55,1.01804,3.6)
.func inv146(y)=table(y,0.0103644,2.3,0.021914,2.35,0.0435823,2.4,0.0767527,2.45,0.126718,2.5,0.180153,2.55,0.263904,2.6,0.349206,2.65,0.44507,2.7,0.547133,2.75,0.625164,2.8,0.692893,2.85,0.750114,2.9,0.799401,2.95,0.84661,3,0.877466,3.05,0.903488,3.1,0.925281,3.15,0.938376,3.2,0.9547,3.25,0.964095,3.3,0.975659,3.35,0.982823,3.4,0.990463,3.45,1,3.5,1.00812,3.55,1.01678,3.6)
.func inv148(y)=table(y,0.0106869,2.3,0.0225106,2.35,0.0446186,2.4,0.0779713,2.45,0.128549,2.5,0.181881,2.55,0.26603,2.6,0.350335,2.65,0.445888,2.7,0.547608,2.75,0.625475,2.8,0.693588,2.85,0.750774,2.9,0.800182,2.95,0.848469,3,0.879059,3.05,0.905306,3.1,0.92712,3.15,0.941025,3.2,0.956579,3.25,0.965695,3.3,0.977439,3.35,0.983872,3.4,0.99098,3.45,1,3.5,1.0074,3.55,1.01552,3.6)
.func pvw(x,ww)=(1-ww)*table(x,3,1.68635,3.25,1.911414,3.5,2.26155,3.75,2.581005,4,2.932957,4.25,3.284919,4.5,3.664267,4.75,4.13185,5,4.478057,5.25,4.912471,5.5,5.335995,5.75,5.776537,6,6.357533,6.25,6.744881,6.5,7.2484,6.75,7.733295,7,8.41118,7.25,8.803405,7.5,9.347171,7.75,9.828414,8,10.57303,8.25,11.03219,8.5,11.57701,8.75,12.2044,9,12.79627,9.25,13.41899,9.5,13.95344,9.75,14.54642)+ww*table(x,3,1.528336,3.25,1.773871,3.5,2.08044,3.75,2.3469,4,2.672786,4.25,2.998138,4.5,3.337052,4.75,3.724933,5,4.189925,5.25,4.523014,5.5,4.928967,5.75,5.382814,6,5.727043,6.25,6.287843,6.5,6.785595,6.75,7.272676,7,7.68492,7.25,8.328276,7.5,8.875771,7.75,9.421652,8,9.985392,8.25,10.57781,8.5,11.14978,8.75,11.7455,9,12.52763,9.25,13.02421,9.5,13.65151,9.75,14.29609)
.func vdq(x,r)=0.5*((x-r*0.25)+sqrt(max(pow(x-r*0.25,2)-4*r*tgt/eta,0)))
.func need(x,r,ww,kdw,ksw,ktw)=tgt/(pvw(max(vdq(x,r),3),ww)*kdw*ksw*ktw)
.func topc(x)=min(min(min(min(min(min(3.5,inv144(need(x,rfc,0.45,kd144,ksa144,ktc))),inv144(need(x,rfs,0.45,kd144,ksa144,kts))),inv146(need(x,rfc,0.55,kd146,ksa146,ktc))),inv146(need(x,rfs,0.55,kd146,ksa146,kts))),inv148(need(x,rfc,0.65,kd148,ksa148,ktc))),inv148(need(x,rfs,0.65,kd148,ksa148,kts)))
Btc tc 0 V=if(tcfix>-500,tcfix,ta+rth*(V(pmod)*(1/eta-1)+pinw_pa))
Rtc tc 0 1meg
.func kt(t)=pow(10,coef*if(ng>0.5,max(t-25,0),t-25)/10)
Bvg vg 0 V=topc(V(p))+vgg
Rvg vg 0 1meg
Bmod pmod 0 V=pv(max(V(d),3))*kd*gv(V(vg))/gref*ks*kt(V(tc))
Rmod pmod 0 1meg
Bpa d 0 I=V(pmod)/(eta*max(V(d),1))
Vp p 0 7.4
Rf p d {rf}
Ibus d 0 0.25
.dc Vp 6.4 8.4 0.05
.save V(d) V(pmod) V(tc) V(vg) I(Vp)
.end
