* coax_a5_bpf.cir: A5 Si5351A CLK1 -> coax -> D-13 drive bandpass -> 18 dB pad -> GVA-84+ -> 3 dB pad -> RA07M1317M input (50 ohm)
* cwht WP-PDR-21 revision 3 (A5), hardware/sim/tx-pa/run_a5_r3.py (record docs/design/analysis/pa-drive-ts012.md)
* 870 steps flattened into one .step (idx): coax length fastest, then corner set, then frequency, then coil Q (nominal bandpass).
* Source, CLK1 pin load, coax, pads and GVA-84+ model as revisions 1 and 2 (run_pa.py); the drive LPF of TS-012
* revision 4 is replaced by the D-13 bandpass (TS-012 revision 7 section 8.14).
.param idx=0
.step param idx 0 869 1
.param ilen=floor(idx/1)-29*floor(idx/29)
.param iset=floor(idx/29)-5*floor(idx/145)
.param ifr=floor(idx/145)-3*floor(idx/435)
.param ib=floor(idx/435)-1*floor(idx/435)
.param iq=floor(idx/435)-2*floor(idx/870)
.param clen=table(ilen,0,0.005,1,0.025,2,0.05,3,0.075,4,0.1,5,0.125,6,0.15,7,0.175,8,0.2,9,0.225,10,0.25,11,0.275,12,0.3,13,0.325,14,0.35,15,0.375,16,0.4,17,0.425,18,0.45,19,0.475,20,0.5,21,0.525,22,0.55,23,0.575,24,0.6,25,0.625,26,0.65,27,0.675,28,0.7)
.param rsrc=table(iset,0,25,1,50,2,50,3,25,4,50)
.param gdb=table(iset,0,25.3,1,25.3,2,24.1,3,22.5,4,22.5)
.param vsat=table(iset,0,3.7669,1,3.7669,2,3.3572,3,2.9921,4,2.9921)
.param vddo=table(iset,0,3.4,1,3.4,2,3.3,3,3.2,4,3.2)
.param tr=table(iset,0,8.33333e-10,1,8.33333e-10,2,1.66667e-09,3,2.5e-09,4,2.5e-09)
.param duty=table(iset,0,0.5,1,0.5,2,0.5,3,0.45,4,0.45)
.param freq=table(ifr,0,1.44e+08,1,1.46e+08,2,1.48e+08)
.param kl=1
.param kc=1
.param dcs=0
.param dcc=0
.param qbpf=table(iq,0,100,1,135)
.param T=1/freq
.param ton=duty*T-tr
.param G=pow(10,gdb/20)
.param p=2.7046
V1 vs 0 PULSE({-duty*vddo} {(1-duty)*vddo} 0 {tr} {tr} {ton} {T})
Rsrc vs clk {rsrc}
* lumped load on the CLK1 pin (main board): prescaler tap 5 pF and stub 2 pF (est.)
Ctap clk 0 5p
Cstub clk 0 2p
* D-8: 50 ohm coax through the bulkhead (lossless; velocity factor 0.66, length clen in metres)
T1 clk 0 lpfin 0 Td={clen/(0.66*299792458)} Z0=50
* D-13 drive bandpass (spurs C10) on the RF board: 1812SMS-47NG (Q {qbpf} at 150 MHz, SRF 2.1 GHz min), C0G
Cs1 lpfin b1 {(7.5+dcs)*1p} Rser=0.1 Lser=0.5n
L1 b1 0 {47.0n*kl} Rser={2*pi*146000000*47.0n*kl/qbpf} Cpar=0.122p
Cr1 b1 0 {16.0p*kc} Rser=0.1 Lser=1n
Cc b1 b2 {(2.4+dcc)*1p} Rser=0.1 Lser=0.5n
L2 b2 0 {47.0n*kl} Rser={2*pi*146000000*47.0n*kl/qbpf} Cpar=0.122p
Cr2 b2 0 {16.0p*kc} Rser=0.1 Lser=1n
Cs2 b2 lpf {(7.5+dcs)*1p} Rser=0.1 Lser=0.5n
* 18 dB input pad (E24 1 %)
Rp1 lpf 0 62.0
Rp2 lpf gin 200.0
Rp3 gin 0 62.0
* GVA-84+ behavioural: 50 ohm input, Rapp limiter, 50 ohm output
Rgin gin 0 50
Bg gs 0 V=2*{G}*V(gin)/pow(1+pow(abs({G}*V(gin))/{vsat},2*{p}),1/(2*{p}))
Rgo gs gout 50
* 3 dB output pad (E24 1 %) and the RA07M1317M input (datasheet ZG = ZL = 50 ohm)
Rq1 gout 0 300.0
Rq2 gout pa_in 18.0
Rq3 pa_in 0 300.0
Rpa pa_in 0 50
.tran 0 250n 228n 20p
.options plotwinsize=0
.save V(clk) V(gin) V(pa_in) I(Rsrc)
.end
