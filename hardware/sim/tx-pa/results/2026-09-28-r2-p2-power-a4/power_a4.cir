* power_a4.cir: A4 AFT05MS004N, output power at the SMA versus pack voltage (cwht WP-PDR-21, hardware/sim/tx-pa, revision 2)
* Pack EMF Vp (swept 6.4 to 8.4 V; equal to the voltage read in receive within 10 mV) behind the drain feed rfeed;
* the 5 V bus (0.25 A, est.) and the PA drain current Pout/(eta*Vd) load the feed, so the key-down sag is solved
* by LTspice, together with the PA case temperature V(tc) of the key-down cases. V(pmod) is the PA output power in
* watts, V(psma) the power at the SMA after the output LPF and relay.
* 13122 corners flattened into one .step (idx), first dimension fastest: irf, ieta, ipin, ifr, in, imatch, iloss, itc.
.param idx=0
.step param idx 0 13121 1
.param irf=floor(idx/1)-3*floor(idx/3)
.param ieta=floor(idx/3)-2*floor(idx/6)
.param ipin=floor(idx/6)-3*floor(idx/18)
.param ifr=floor(idx/18)-3*floor(idx/54)
.param in=floor(idx/54)-3*floor(idx/162)
.param imatch=floor(idx/162)-3*floor(idx/486)
.param iloss=floor(idx/486)-3*floor(idx/1458)
.param itc=floor(idx/1458)-9*floor(idx/13122)
* temperature cases (itc): 0 25 C, start of key-down (case 25 C); 1 25 C, key-down, -0.005 dB/K; 2 25 C, key-down, -0.015 dB/K; 3 -10 C, key-down, PA no cold gain; 4 -10 C, start of key-down, PA +0.53 dB; 5 +45 C, key-down, -0.005 dB/K; 6 +45 C, key-down, -0.015 dB/K; 7 +45 C, case 100 C bound, -0.005 dB/K; 8 +45 C, case 100 C bound, -0.015 dB/K
.param rf=table(itc*3+irf,0,0.26,1,0.35,2,0.45,3,0.27562,4,0.39358,5,0.53392,6,0.27562,7,0.39358,8,0.53392,9,0.31831,10,0.45231,11,0.61301,12,0.30269,13,0.40874,14,0.52909,15,0.29294,16,0.41811,17,0.56758,18,0.29294,19,0.41811,20,0.56758,21,0.29294,22,0.41811,23,0.56758,24,0.29294,25,0.41811,26,0.56758)
* ambient (C); fixed PA case (C; -999: solved from the dissipation); PA coefficient (dB/K above 25 C);
* no gain below a 25 C case (1) or the full law (0); copper term (dB per dB of LPF loss)
.param ta=table(itc,0,25,1,25,2,25,3,-10,4,-10,5,45,6,45,7,45,8,45)
.param tcfix=table(itc,0,25,1,-999,2,-999,3,-999,4,-10,5,-999,6,-999,7,100,8,100)
.param coef=table(itc,0,-0.015,1,-0.005,2,-0.015,3,-0.015,4,-0.015,5,-0.005,6,-0.015,7,-0.005,8,-0.015)
.param ng=table(itc,0,1,1,1,2,1,3,1,4,0,5,1,6,1,7,1,8,1)
.param cu=table(itc,0,0,1,0.0858,2,0.0858,3,0.01755,4,-0.06825,5,0.1248,6,0.1248,7,0.1248,8,0.1248)
.param rth=9.6
.param pinw_pa=pin
.param pin=table(ipin,0,0.0458425,1,0.0894078,2,0.179968)
.param fr=table(ifr,0,1.44e+08,1,1.46e+08,2,1.48e+08)
.param loss=table(iloss,0,0.5,1,0.84,2,1.86)
.param w=(fr-135e6)/20e6
.param kloss=pow(10,-(loss+(loss-0.1)*cu)/10)
.param eta=table(ieta,0,0.55,1,0.67)
.param n=table(in,0,1.8,1,2,2,2.3)
.param match=table(imatch,0,0,1,0.25,2,0.5)
.param pinw=pin
.param kmatch=pow(10,-match/10)
* AFT05MS004N: Pout at 7.5 V versus Pin, NXP reference circuit (Figure 13, 135 and 155 MHz, interpolated in f)
.param p75=(1-w)*table(pinw,0.02,1.067,0.02244,1.2452,0.02518,1.4493,0.02825,1.6745,0.0317,1.9349,0.03557,2.2573,0.03991,2.6091,0.04477,3.0188,0.05024,3.4559,0.05637,3.9546,0.06325,4.4676,0.07096,4.9542,0.07962,5.4248,0.08934,5.7587,0.10024,6.0906,0.11247,6.2488,0.12619,6.3685,0.14159,6.4569,0.15887,6.5328,0.17825,6.5752,0.2,6.6442)+w*table(pinw,0.02,2.1564,0.02244,2.5188,0.02518,2.8976,0.02825,3.2758,0.0317,3.6951,0.03557,4.2096,0.03991,4.7087,0.04477,5.2142,0.05024,5.7041,0.05637,6.1085,0.06325,6.4639,0.07096,6.7409,0.07962,6.9604,0.08934,7.1486,0.10024,7.2943,0.11247,7.4191,0.12619,7.5297,0.14159,7.6192,0.15887,7.7041,0.17825,7.7764,0.2,7.7693)
* PA case temperature: fixed, or ambient plus Rth_ca times the PA dissipation Pout (1/eta - 1) + Pin (WP-PDR-28)
Btc tc 0 V=if(tcfix>-500,tcfix,ta+rth*(V(pmod)*(1/eta-1)+pinw_pa))
Rtc tc 0 1meg
.func kt(t)=pow(10,coef*if(ng>0.5,max(t-25,0),t-25)/10)
Bmod pmod 0 V=p75*pow(max(V(d),1)/7.5,n)*kmatch*kt(V(tc))
Rmod pmod 0 1meg
Bpa d 0 I=V(pmod)/(eta*max(V(d),1))
Vp p 0 7.4
Rf p d {rf}
Ibus d 0 0.25
Bsma psma 0 V=V(pmod)*kloss
Rsma psma 0 1meg
.dc Vp 6.4 8.4 0.05
.save V(d) V(pmod) V(psma) V(tc) I(Vp)
.end
